* extracted by klt extract --deck sky130

* cell integrator
* pin dn
* pin dp
* pin ibias
* pin inn
* pin inp
* pin outn,voutn
* pin outp,voutp
* pin phi1
* pin phi1b
* pin phi1e
* pin phi2
* pin vcm
* pin vdda
* pin vinn
* pin vinp
* pin vrefn
* pin vrefp
* pin vssa
.SUBCKT integrator dn dp ibias inn inp outn|voutn outp|voutp phi1 phi1b phi1e
+ phi2 vcm vdda vinn vinp vrefn vrefp vssa
* device instance $1 r0 *1 4.67,55.39 nfet
X$1 vrefn dn \$6 vssa sky130_fd_pr__nfet_01v8 L=0.15 W=4 AS=1.88 AD=1.88
+ PS=8.94 PD=8.94
* device instance $2 r0 *1 20.01,55.39 nfet
X$2 vrefp dp \$6 vssa sky130_fd_pr__nfet_01v8 L=0.15 W=4 AS=1.88 AD=1.88
+ PS=8.94 PD=8.94
* device instance $3 r0 *1 50.69,55.39 nfet
X$3 \$6 phi1 \$9 vssa sky130_fd_pr__nfet_01v8 L=0.15 W=4 AS=1.88 AD=1.88
+ PS=8.94 PD=8.94
* device instance $4 r0 *1 145.515,113.27 nfet
X$4 ibias ibias vssa vssa sky130_fd_pr__nfet_01v8 L=0.5 W=2 AS=0.84 AD=0.84
+ PS=4.84 PD=4.84
* device instance $5 r0 *1 151.105,113.27 nfet
X$5 \$23 ibias vssa vssa sky130_fd_pr__nfet_01v8 L=0.5 W=2 AS=0.84 AD=0.84
+ PS=4.84 PD=4.84
* device instance $6 r0 *1 156.695,113.27 nfet
X$6 \$36 ibias vssa vssa sky130_fd_pr__nfet_01v8 L=0.5 W=2 AS=0.84 AD=0.84
+ PS=4.84 PD=4.84
* device instance $7 r0 *1 162.535,112.48 nfet
X$7 \$24 \$24 vssa vssa sky130_fd_pr__nfet_01v8 L=1 W=0.42 AS=0.1764 AD=0.1764
+ PS=1.68 PD=1.68
* device instance $8 r0 *1 174.885,113.27 nfet
X$8 \$25 \$17 \$30 vssa sky130_fd_pr__nfet_01v8 L=0.5 W=2 AS=0.84 AD=0.84
+ PS=4.84 PD=4.84
* device instance $9 r0 *1 176.625,113.27 nfet
X$9 \$26 vcm \$30 vssa sky130_fd_pr__nfet_01v8 L=0.5 W=2 AS=0.84 AD=0.84
+ PS=4.84 PD=4.84
* device instance $10 r0 *1 201.605,113.27 nfet
X$10 \$27 ibias vssa vssa sky130_fd_pr__nfet_01v8 L=0.5 W=2 AS=0.84 AD=0.84
+ PS=4.84 PD=4.84
* device instance $11 r0 *1 203.345,113.27 nfet
X$11 \$28 ibias vssa vssa sky130_fd_pr__nfet_01v8 L=0.5 W=2 AS=0.84 AD=0.84
+ PS=4.84 PD=4.84
* device instance $12 r0 *1 205.085,113.27 nfet
X$12 \$27 ibias vssa vssa sky130_fd_pr__nfet_01v8 L=0.5 W=2 AS=0.84 AD=0.84
+ PS=4.84 PD=4.84
* device instance $13 r0 *1 206.825,113.27 nfet
X$13 \$28 ibias vssa vssa sky130_fd_pr__nfet_01v8 L=0.5 W=2 AS=0.84 AD=0.84
+ PS=4.84 PD=4.84
* device instance $14 r0 *1 208.565,113.27 nfet
X$14 \$27 ibias vssa vssa sky130_fd_pr__nfet_01v8 L=0.5 W=2 AS=0.84 AD=0.84
+ PS=4.84 PD=4.84
* device instance $15 r0 *1 210.305,113.27 nfet
X$15 \$28 ibias vssa vssa sky130_fd_pr__nfet_01v8 L=0.5 W=2 AS=0.84 AD=0.84
+ PS=4.84 PD=4.84
* device instance $16 r0 *1 212.045,113.27 nfet
X$16 \$27 ibias vssa vssa sky130_fd_pr__nfet_01v8 L=0.5 W=2 AS=0.84 AD=0.84
+ PS=4.84 PD=4.84
* device instance $17 r0 *1 213.785,113.27 nfet
X$17 \$28 ibias vssa vssa sky130_fd_pr__nfet_01v8 L=0.5 W=2 AS=0.84 AD=0.84
+ PS=4.84 PD=4.84
* device instance $18 r0 *1 168.375,113.94 nfet
X$18 \$30 ibias vssa vssa sky130_fd_pr__nfet_01v8 L=0.5 W=2 AS=0.84 AD=0.42
+ PS=4.84 PD=2.42
* device instance $19 r0 *1 169.295,113.94 nfet
X$19 vssa ibias \$30 vssa sky130_fd_pr__nfet_01v8 L=0.5 W=2 AS=0.42 AD=0.84
+ PS=2.42 PD=4.84
* device instance $20 r0 *1 174.885,116.79 nfet
X$20 \$26 vcm \$30 vssa sky130_fd_pr__nfet_01v8 L=0.5 W=2 AS=0.84 AD=0.84
+ PS=4.84 PD=4.84
* device instance $21 r0 *1 176.625,116.79 nfet
X$21 \$25 \$17 \$30 vssa sky130_fd_pr__nfet_01v8 L=0.5 W=2 AS=0.84 AD=0.84
+ PS=4.84 PD=4.84
* device instance $22 r0 *1 182.215,113.94 nfet
X$22 \$31 ibias vssa vssa sky130_fd_pr__nfet_01v8 L=0.5 W=2 AS=0.84 AD=0.42
+ PS=4.84 PD=2.42
* device instance $23 r0 *1 183.135,113.94 nfet
X$23 vssa ibias \$31 vssa sky130_fd_pr__nfet_01v8 L=0.5 W=2 AS=0.42 AD=0.42
+ PS=2.42 PD=2.42
* device instance $24 r0 *1 184.055,113.94 nfet
X$24 \$31 ibias vssa vssa sky130_fd_pr__nfet_01v8 L=0.5 W=2 AS=0.42 AD=0.42
+ PS=2.42 PD=2.42
* device instance $25 r0 *1 184.975,113.94 nfet
X$25 vssa ibias \$31 vssa sky130_fd_pr__nfet_01v8 L=0.5 W=2 AS=0.42 AD=0.42
+ PS=2.42 PD=2.42
* device instance $26 r0 *1 185.895,113.94 nfet
X$26 \$31 ibias vssa vssa sky130_fd_pr__nfet_01v8 L=0.5 W=2 AS=0.42 AD=0.42
+ PS=2.42 PD=2.42
* device instance $27 r0 *1 186.815,113.94 nfet
X$27 vssa ibias \$31 vssa sky130_fd_pr__nfet_01v8 L=0.5 W=2 AS=0.42 AD=0.42
+ PS=2.42 PD=2.42
* device instance $28 r0 *1 187.735,113.94 nfet
X$28 \$31 ibias vssa vssa sky130_fd_pr__nfet_01v8 L=0.5 W=2 AS=0.42 AD=0.42
+ PS=2.42 PD=2.42
* device instance $29 r0 *1 188.655,113.94 nfet
X$29 vssa ibias \$31 vssa sky130_fd_pr__nfet_01v8 L=0.5 W=2 AS=0.42 AD=0.42
+ PS=2.42 PD=2.42
* device instance $30 r0 *1 189.575,113.94 nfet
X$30 \$31 ibias vssa vssa sky130_fd_pr__nfet_01v8 L=0.5 W=2 AS=0.42 AD=0.42
+ PS=2.42 PD=2.42
* device instance $31 r0 *1 190.495,113.94 nfet
X$31 vssa ibias \$31 vssa sky130_fd_pr__nfet_01v8 L=0.5 W=2 AS=0.42 AD=0.42
+ PS=2.42 PD=2.42
* device instance $32 r0 *1 191.415,113.94 nfet
X$32 \$31 ibias vssa vssa sky130_fd_pr__nfet_01v8 L=0.5 W=2 AS=0.42 AD=0.42
+ PS=2.42 PD=2.42
* device instance $33 r0 *1 192.335,113.94 nfet
X$33 vssa ibias \$31 vssa sky130_fd_pr__nfet_01v8 L=0.5 W=2 AS=0.42 AD=0.42
+ PS=2.42 PD=2.42
* device instance $34 r0 *1 193.255,113.94 nfet
X$34 \$31 ibias vssa vssa sky130_fd_pr__nfet_01v8 L=0.5 W=2 AS=0.42 AD=0.42
+ PS=2.42 PD=2.42
* device instance $35 r0 *1 194.175,113.94 nfet
X$35 vssa ibias \$31 vssa sky130_fd_pr__nfet_01v8 L=0.5 W=2 AS=0.42 AD=0.42
+ PS=2.42 PD=2.42
* device instance $36 r0 *1 195.095,113.94 nfet
X$36 \$31 ibias vssa vssa sky130_fd_pr__nfet_01v8 L=0.5 W=2 AS=0.42 AD=0.42
+ PS=2.42 PD=2.42
* device instance $37 r0 *1 196.015,113.94 nfet
X$37 vssa ibias \$31 vssa sky130_fd_pr__nfet_01v8 L=0.5 W=2 AS=0.42 AD=0.84
+ PS=2.42 PD=4.84
* device instance $38 r0 *1 201.605,116.79 nfet
X$38 \$28 ibias vssa vssa sky130_fd_pr__nfet_01v8 L=0.5 W=2 AS=0.84 AD=0.84
+ PS=4.84 PD=4.84
* device instance $39 r0 *1 203.345,116.79 nfet
X$39 \$27 ibias vssa vssa sky130_fd_pr__nfet_01v8 L=0.5 W=2 AS=0.84 AD=0.84
+ PS=4.84 PD=4.84
* device instance $40 r0 *1 205.085,116.79 nfet
X$40 \$28 ibias vssa vssa sky130_fd_pr__nfet_01v8 L=0.5 W=2 AS=0.84 AD=0.84
+ PS=4.84 PD=4.84
* device instance $41 r0 *1 206.825,116.79 nfet
X$41 \$27 ibias vssa vssa sky130_fd_pr__nfet_01v8 L=0.5 W=2 AS=0.84 AD=0.84
+ PS=4.84 PD=4.84
* device instance $42 r0 *1 208.565,116.79 nfet
X$42 \$28 ibias vssa vssa sky130_fd_pr__nfet_01v8 L=0.5 W=2 AS=0.84 AD=0.84
+ PS=4.84 PD=4.84
* device instance $43 r0 *1 210.305,116.79 nfet
X$43 \$27 ibias vssa vssa sky130_fd_pr__nfet_01v8 L=0.5 W=2 AS=0.84 AD=0.84
+ PS=4.84 PD=4.84
* device instance $44 r0 *1 212.045,116.79 nfet
X$44 \$28 ibias vssa vssa sky130_fd_pr__nfet_01v8 L=0.5 W=2 AS=0.84 AD=0.84
+ PS=4.84 PD=4.84
* device instance $45 r0 *1 213.785,116.79 nfet
X$45 \$27 ibias vssa vssa sky130_fd_pr__nfet_01v8 L=0.5 W=2 AS=0.84 AD=0.84
+ PS=4.84 PD=4.84
* device instance $46 r0 *1 4.67,231.47 nfet
X$46 vrefp dn \$40 vssa sky130_fd_pr__nfet_01v8 L=0.15 W=4 AS=1.88 AD=1.88
+ PS=8.94 PD=8.94
* device instance $47 r0 *1 20.01,231.47 nfet
X$47 vrefn dp \$40 vssa sky130_fd_pr__nfet_01v8 L=0.15 W=4 AS=1.88 AD=1.88
+ PS=8.94 PD=8.94
* device instance $48 r0 *1 50.69,231.47 nfet
X$48 \$40 phi1 \$41 vssa sky130_fd_pr__nfet_01v8 L=0.15 W=4 AS=1.88 AD=1.88
+ PS=8.94 PD=8.94
* device instance $49 r0 *1 145.515,133.91 nfet
X$49 \$32 inp \$31 vssa sky130_fd_pr__nfet_01v8 L=0.5 W=8 AS=3.36 AD=3.36
+ PS=16.84 PD=16.84
* device instance $50 r0 *1 145.515,143.43 nfet
X$50 \$33 inn \$31 vssa sky130_fd_pr__nfet_01v8 L=0.5 W=8 AS=3.36 AD=3.36
+ PS=16.84 PD=16.84
* device instance $51 r0 *1 147.255,143.43 nfet
X$51 \$32 inp \$31 vssa sky130_fd_pr__nfet_01v8 L=0.5 W=8 AS=3.36 AD=3.36
+ PS=16.84 PD=16.84
* device instance $52 r0 *1 147.255,133.91 nfet
X$52 \$33 inn \$31 vssa sky130_fd_pr__nfet_01v8 L=0.5 W=8 AS=3.36 AD=3.36
+ PS=16.84 PD=16.84
* device instance $53 r0 *1 154.845,141.93 nfet
X$53 outp|voutp \$24 \$28 vssa sky130_fd_pr__nfet_01v8 L=0.5 W=7 AS=2.94
+ AD=2.94 PS=14.84 PD=14.84
* device instance $54 r0 *1 154.845,133.41 nfet
X$54 outn|voutn \$24 \$27 vssa sky130_fd_pr__nfet_01v8 L=0.5 W=7 AS=2.94
+ AD=2.94 PS=14.84 PD=14.84
* device instance $55 r0 *1 156.585,141.93 nfet
X$55 outn|voutn \$24 \$27 vssa sky130_fd_pr__nfet_01v8 L=0.5 W=7 AS=2.94
+ AD=2.94 PS=14.84 PD=14.84
* device instance $56 r0 *1 156.585,133.41 nfet
X$56 outp|voutp \$24 \$28 vssa sky130_fd_pr__nfet_01v8 L=0.5 W=7 AS=2.94
+ AD=2.94 PS=14.84 PD=14.84
* device instance $57 r0 *1 4.67,295.68 nfet
X$57 \$1 phi2 vssa vssa sky130_fd_pr__nfet_01v8 L=0.15 W=2 AS=0.94 AD=0.52
+ PS=4.94 PD=2.52
* device instance $58 r0 *1 5.34,295.68 nfet
X$58 vssa phi2 \$1 vssa sky130_fd_pr__nfet_01v8 L=0.15 W=2 AS=0.52 AD=0.52
+ PS=2.52 PD=2.52
* device instance $59 r0 *1 6.01,295.68 nfet
X$59 \$1 phi2 vssa vssa sky130_fd_pr__nfet_01v8 L=0.15 W=2 AS=0.52 AD=0.52
+ PS=2.52 PD=2.52
* device instance $60 r0 *1 6.68,295.68 nfet
X$60 vssa phi2 \$1 vssa sky130_fd_pr__nfet_01v8 L=0.15 W=2 AS=0.52 AD=0.94
+ PS=2.52 PD=4.94
* device instance $61 r0 *1 4.695,27.27 pfet
X$61 vrefn dp \$6 vdda sky130_fd_pr__pfet_01v8 L=0.15 W=8 AS=3.76 AD=3.76
+ PS=16.94 PD=16.94
* device instance $62 r0 *1 20.085,27.27 pfet
X$62 vrefp dn \$6 vdda sky130_fd_pr__pfet_01v8 L=0.15 W=8 AS=3.76 AD=3.76
+ PS=16.94 PD=16.94
* device instance $63 r0 *1 50.965,27.27 pfet
X$63 \$6 phi1b \$9 vdda sky130_fd_pr__pfet_01v8 L=0.15 W=8 AS=3.76 AD=3.76
+ PS=16.94 PD=16.94
* device instance $64 r0 *1 145.54,164.55 pfet
X$64 \$32 \$26 vdda vdda sky130_fd_pr__pfet_01v8 L=0.5 W=10 AS=4.2 AD=4.2
+ PS=20.84 PD=20.84
* device instance $65 r0 *1 147.28,164.55 pfet
X$65 \$33 \$26 vdda vdda sky130_fd_pr__pfet_01v8 L=0.5 W=10 AS=4.2 AD=4.2
+ PS=20.84 PD=20.84
* device instance $66 r0 *1 149.02,164.55 pfet
X$66 \$32 \$26 vdda vdda sky130_fd_pr__pfet_01v8 L=0.5 W=10 AS=4.2 AD=4.2
+ PS=20.84 PD=20.84
* device instance $67 r0 *1 150.76,164.55 pfet
X$67 \$33 \$26 vdda vdda sky130_fd_pr__pfet_01v8 L=0.5 W=10 AS=4.2 AD=4.2
+ PS=20.84 PD=20.84
* device instance $68 r0 *1 152.5,164.55 pfet
X$68 \$32 \$26 vdda vdda sky130_fd_pr__pfet_01v8 L=0.5 W=10 AS=4.2 AD=4.2
+ PS=20.84 PD=20.84
* device instance $69 r0 *1 154.24,164.55 pfet
X$69 \$33 \$26 vdda vdda sky130_fd_pr__pfet_01v8 L=0.5 W=10 AS=4.2 AD=4.2
+ PS=20.84 PD=20.84
* device instance $70 r0 *1 155.98,164.55 pfet
X$70 \$32 \$26 vdda vdda sky130_fd_pr__pfet_01v8 L=0.5 W=10 AS=4.2 AD=4.2
+ PS=20.84 PD=20.84
* device instance $71 r0 *1 157.72,164.55 pfet
X$71 \$33 \$26 vdda vdda sky130_fd_pr__pfet_01v8 L=0.5 W=10 AS=4.2 AD=4.2
+ PS=20.84 PD=20.84
* device instance $72 r0 *1 163.36,164.55 pfet
X$72 outn|voutn \$36 \$32 vdda sky130_fd_pr__pfet_01v8 L=0.5 W=10 AS=4.2 AD=4.2
+ PS=20.84 PD=20.84
* device instance $73 r0 *1 165.1,164.55 pfet
X$73 outp|voutp \$36 \$33 vdda sky130_fd_pr__pfet_01v8 L=0.5 W=10 AS=4.2 AD=4.2
+ PS=20.84 PD=20.84
* device instance $74 r0 *1 166.84,164.55 pfet
X$74 outn|voutn \$36 \$32 vdda sky130_fd_pr__pfet_01v8 L=0.5 W=10 AS=4.2 AD=4.2
+ PS=20.84 PD=20.84
* device instance $75 r0 *1 168.58,164.55 pfet
X$75 outp|voutp \$36 \$33 vdda sky130_fd_pr__pfet_01v8 L=0.5 W=10 AS=4.2 AD=4.2
+ PS=20.84 PD=20.84
* device instance $76 r0 *1 174.22,160.8 pfet
X$76 \$25 \$25 vdda vdda sky130_fd_pr__pfet_01v8 L=0.5 W=2.5 AS=1.05 AD=1.05
+ PS=5.84 PD=5.84
* device instance $77 r0 *1 175.96,160.8 pfet
X$77 \$26 \$25 vdda vdda sky130_fd_pr__pfet_01v8 L=0.5 W=2.5 AS=1.05 AD=1.05
+ PS=5.84 PD=5.84
* device instance $78 r0 *1 181.6,162.05 pfet
X$78 \$23 \$23 vdda vdda sky130_fd_pr__pfet_01v8 L=0.5 W=5 AS=2.1 AD=2.1
+ PS=10.84 PD=10.84
* device instance $79 r0 *1 187.24,162.05 pfet
X$79 \$24 \$23 vdda vdda sky130_fd_pr__pfet_01v8 L=0.5 W=5 AS=2.1 AD=2.1
+ PS=10.84 PD=10.84
* device instance $80 r0 *1 192.93,159.76 pfet
X$80 \$36 \$36 vdda vdda sky130_fd_pr__pfet_01v8 L=0.6 W=0.42 AS=0.1764
+ AD=0.1764 PS=1.68 PD=1.68
* device instance $81 r0 *1 4.695,259.59 pfet
X$81 vrefp dp \$40 vdda sky130_fd_pr__pfet_01v8 L=0.15 W=8 AS=3.76 AD=3.76
+ PS=16.94 PD=16.94
* device instance $82 r0 *1 20.085,259.59 pfet
X$82 vrefn dn \$40 vdda sky130_fd_pr__pfet_01v8 L=0.15 W=8 AS=3.76 AD=3.76
+ PS=16.94 PD=16.94
* device instance $83 r0 *1 50.965,259.59 pfet
X$83 \$40 phi1b \$41 vdda sky130_fd_pr__pfet_01v8 L=0.15 W=8 AS=3.76 AD=3.76
+ PS=16.94 PD=16.94
* device instance $84 r0 *1 145.54,176.07 pfet
X$84 \$33 \$26 vdda vdda sky130_fd_pr__pfet_01v8 L=0.5 W=10 AS=4.2 AD=4.2
+ PS=20.84 PD=20.84
* device instance $85 r0 *1 147.28,176.07 pfet
X$85 \$32 \$26 vdda vdda sky130_fd_pr__pfet_01v8 L=0.5 W=10 AS=4.2 AD=4.2
+ PS=20.84 PD=20.84
* device instance $86 r0 *1 149.02,176.07 pfet
X$86 \$33 \$26 vdda vdda sky130_fd_pr__pfet_01v8 L=0.5 W=10 AS=4.2 AD=4.2
+ PS=20.84 PD=20.84
* device instance $87 r0 *1 150.76,176.07 pfet
X$87 \$32 \$26 vdda vdda sky130_fd_pr__pfet_01v8 L=0.5 W=10 AS=4.2 AD=4.2
+ PS=20.84 PD=20.84
* device instance $88 r0 *1 152.5,176.07 pfet
X$88 \$33 \$26 vdda vdda sky130_fd_pr__pfet_01v8 L=0.5 W=10 AS=4.2 AD=4.2
+ PS=20.84 PD=20.84
* device instance $89 r0 *1 154.24,176.07 pfet
X$89 \$32 \$26 vdda vdda sky130_fd_pr__pfet_01v8 L=0.5 W=10 AS=4.2 AD=4.2
+ PS=20.84 PD=20.84
* device instance $90 r0 *1 155.98,176.07 pfet
X$90 \$33 \$26 vdda vdda sky130_fd_pr__pfet_01v8 L=0.5 W=10 AS=4.2 AD=4.2
+ PS=20.84 PD=20.84
* device instance $91 r0 *1 157.72,176.07 pfet
X$91 \$32 \$26 vdda vdda sky130_fd_pr__pfet_01v8 L=0.5 W=10 AS=4.2 AD=4.2
+ PS=20.84 PD=20.84
* device instance $92 r0 *1 163.36,176.07 pfet
X$92 outp|voutp \$36 \$33 vdda sky130_fd_pr__pfet_01v8 L=0.5 W=10 AS=4.2 AD=4.2
+ PS=20.84 PD=20.84
* device instance $93 r0 *1 165.1,176.07 pfet
X$93 outn|voutn \$36 \$32 vdda sky130_fd_pr__pfet_01v8 L=0.5 W=10 AS=4.2 AD=4.2
+ PS=20.84 PD=20.84
* device instance $94 r0 *1 166.84,176.07 pfet
X$94 outp|voutp \$36 \$33 vdda sky130_fd_pr__pfet_01v8 L=0.5 W=10 AS=4.2 AD=4.2
+ PS=20.84 PD=20.84
* device instance $95 r0 *1 168.58,176.07 pfet
X$95 outn|voutn \$36 \$32 vdda sky130_fd_pr__pfet_01v8 L=0.5 W=10 AS=4.2 AD=4.2
+ PS=20.84 PD=20.84
* device instance $96 r0 *1 174.22,164.82 pfet
X$96 \$26 \$25 vdda vdda sky130_fd_pr__pfet_01v8 L=0.5 W=2.5 AS=1.05 AD=1.05
+ PS=5.84 PD=5.84
* device instance $97 r0 *1 175.96,164.82 pfet
X$97 \$25 \$25 vdda vdda sky130_fd_pr__pfet_01v8 L=0.5 W=2.5 AS=1.05 AD=1.05
+ PS=5.84 PD=5.84
* device instance $98 r0 *1 4.695,310.29 pfet
X$98 vdda phi2 \$1 vdda sky130_fd_pr__pfet_01v8 L=0.15 W=4 AS=1.88 AD=1.04
+ PS=8.94 PD=4.52
* device instance $99 r0 *1 5.365,310.29 pfet
X$99 \$1 phi2 vdda vdda sky130_fd_pr__pfet_01v8 L=0.15 W=4 AS=1.04 AD=1.04
+ PS=4.52 PD=4.52
* device instance $100 r0 *1 6.035,310.29 pfet
X$100 vdda phi2 \$1 vdda sky130_fd_pr__pfet_01v8 L=0.15 W=4 AS=1.04 AD=1.04
+ PS=4.52 PD=4.52
* device instance $101 r0 *1 6.705,310.29 pfet
X$101 \$1 phi2 vdda vdda sky130_fd_pr__pfet_01v8 L=0.15 W=4 AS=1.04 AD=1.88
+ PS=4.52 PD=8.94
* device instance $102 r0 *1 35.35,55.39 nfet
X$102 vinn phi1 \$7 vssa sky130_fd_pr__nfet_01v8_lvt L=0.15 W=4 AS=1.88 AD=1.88
+ PS=8.94 PD=8.94
* device instance $103 r0 *1 66.03,51.39 nfet
X$103 \$7 phi2 vcm vssa sky130_fd_pr__nfet_01v8_lvt L=0.15 W=12 AS=5.64 AD=5.64
+ PS=24.94 PD=24.94
* device instance $104 r0 *1 81.37,51.39 nfet
X$104 \$9 phi2 vcm vssa sky130_fd_pr__nfet_01v8_lvt L=0.15 W=12 AS=5.64 AD=5.64
+ PS=24.94 PD=24.94
* device instance $105 r0 *1 96.71,51.39 nfet
X$105 \$12 phi1e vcm vssa sky130_fd_pr__nfet_01v8_lvt L=0.15 W=12 AS=5.64
+ AD=5.64 PS=24.94 PD=24.94
* device instance $106 r0 *1 112.05,51.39 nfet
X$106 \$18 phi1e vcm vssa sky130_fd_pr__nfet_01v8_lvt L=0.15 W=12 AS=5.64
+ AD=5.64 PS=24.94 PD=24.94
* device instance $107 r0 *1 96.71,134.28 nfet
X$107 \$12 phi2 inp vssa sky130_fd_pr__nfet_01v8_lvt L=0.15 W=12 AS=5.64
+ AD=5.64 PS=24.94 PD=24.94
* device instance $108 r0 *1 112.05,134.28 nfet
X$108 \$18 phi2 inp vssa sky130_fd_pr__nfet_01v8_lvt L=0.15 W=12 AS=5.64
+ AD=5.64 PS=24.94 PD=24.94
* device instance $109 r0 *1 96.71,152.58 nfet
X$109 \$38 phi2 inn vssa sky130_fd_pr__nfet_01v8_lvt L=0.15 W=12 AS=5.64
+ AD=5.64 PS=24.94 PD=24.94
* device instance $110 r0 *1 112.05,152.58 nfet
X$110 \$37 phi2 inn vssa sky130_fd_pr__nfet_01v8_lvt L=0.15 W=12 AS=5.64
+ AD=5.64 PS=24.94 PD=24.94
* device instance $111 r0 *1 35.35,231.47 nfet
X$111 vinp phi1 \$39 vssa sky130_fd_pr__nfet_01v8_lvt L=0.15 W=4 AS=1.88
+ AD=1.88 PS=8.94 PD=8.94
* device instance $112 r0 *1 66.03,235.47 nfet
X$112 \$39 phi2 vcm vssa sky130_fd_pr__nfet_01v8_lvt L=0.15 W=12 AS=5.64
+ AD=5.64 PS=24.94 PD=24.94
* device instance $113 r0 *1 81.37,235.47 nfet
X$113 \$41 phi2 vcm vssa sky130_fd_pr__nfet_01v8_lvt L=0.15 W=12 AS=5.64
+ AD=5.64 PS=24.94 PD=24.94
* device instance $114 r0 *1 96.71,235.47 nfet
X$114 \$38 phi1e vcm vssa sky130_fd_pr__nfet_01v8_lvt L=0.15 W=12 AS=5.64
+ AD=5.64 PS=24.94 PD=24.94
* device instance $115 r0 *1 112.05,235.47 nfet
X$115 \$37 phi1e vcm vssa sky130_fd_pr__nfet_01v8_lvt L=0.15 W=12 AS=5.64
+ AD=5.64 PS=24.94 PD=24.94
* device instance $116 r0 *1 35.525,27.27 pfet
X$116 vinn phi1b \$7 vdda sky130_fd_pr__pfet_01v8_lvt L=0.35 W=8 AS=3.36
+ AD=3.36 PS=16.84 PD=16.84
* device instance $117 r0 *1 66.405,19.27 pfet
X$117 \$7 \$1 vcm vdda sky130_fd_pr__pfet_01v8_lvt L=0.35 W=24 AS=10.08
+ AD=10.08 PS=48.84 PD=48.84
* device instance $118 r0 *1 81.895,19.27 pfet
X$118 \$9 \$1 vcm vdda sky130_fd_pr__pfet_01v8_lvt L=0.35 W=24 AS=10.08
+ AD=10.08 PS=48.84 PD=48.84
* device instance $119 r0 *1 96.485,115.16 pfet
X$119 \$12 \$1 inp vdda sky130_fd_pr__pfet_01v8_lvt L=0.35 W=4 AS=1.68 AD=1.68
+ PS=8.84 PD=8.84
* device instance $120 r0 *1 111.975,115.16 pfet
X$120 \$18 \$1 inp vdda sky130_fd_pr__pfet_01v8_lvt L=0.35 W=4 AS=1.68 AD=1.68
+ PS=8.84 PD=8.84
* device instance $121 r0 *1 96.485,171.7 pfet
X$121 \$38 \$1 inn vdda sky130_fd_pr__pfet_01v8_lvt L=0.35 W=4 AS=1.68 AD=1.68
+ PS=8.84 PD=8.84
* device instance $122 r0 *1 111.975,171.7 pfet
X$122 \$37 \$1 inn vdda sky130_fd_pr__pfet_01v8_lvt L=0.35 W=4 AS=1.68 AD=1.68
+ PS=8.84 PD=8.84
* device instance $123 r0 *1 35.525,259.59 pfet
X$123 vinp phi1b \$39 vdda sky130_fd_pr__pfet_01v8_lvt L=0.35 W=8 AS=3.36
+ AD=3.36 PS=16.84 PD=16.84
* device instance $124 r0 *1 66.405,267.59 pfet
X$124 \$39 \$1 vcm vdda sky130_fd_pr__pfet_01v8_lvt L=0.35 W=24 AS=10.08
+ AD=10.08 PS=48.84 PD=48.84
* device instance $125 r0 *1 81.895,267.59 pfet
X$125 \$41 \$1 vcm vdda sky130_fd_pr__pfet_01v8_lvt L=0.35 W=24 AS=10.08
+ AD=10.08 PS=48.84 PD=48.84
* device instance $126 r0 *1 94.555,84.755 sky130_fd_pr__model__cap_mim
X$126 outn|voutn inp sky130_fd_pr__cap_mim_m3_1 l=31.43 w=31.43
* device instance $127 r0 *1 94.555,202.105 sky130_fd_pr__model__cap_mim
X$127 outp|voutp inn sky130_fd_pr__cap_mim_m3_1 l=31.43 w=31.43
* device instance $128 r0 *1 52.755,89.385 sky130_fd_pr__model__cap_mim
X$128 \$7 \$12 sky130_fd_pr__cap_mim_m3_1 l=22.17 w=22.17
* device instance $129 r0 *1 52.755,197.475 sky130_fd_pr__model__cap_mim
X$129 \$39 \$38 sky130_fd_pr__cap_mim_m3_1 l=22.17 w=22.17
* device instance $130 r0 *1 15.585,89.385 sky130_fd_pr__model__cap_mim
X$130 \$9 \$18 sky130_fd_pr__cap_mim_m3_1 l=22.17 w=22.17
* device instance $131 r0 *1 15.585,197.475 sky130_fd_pr__model__cap_mim
X$131 \$41 \$37 sky130_fd_pr__cap_mim_m3_1 l=22.17 w=22.17
* device instance $132 r0 *1 195.955,59.035 sky130_fd_pr__model__cap_mim
X$132 outp|voutp \$17 sky130_fd_pr__cap_mim_m3_1 l=7.07 w=7.07
* device instance $133 r0 *1 205.525,59.035 sky130_fd_pr__model__cap_mim
X$133 outn|voutn \$17 sky130_fd_pr__cap_mim_m3_1 l=7.07 w=7.07
* device instance $134 r0 *1 163.32,77.6 sky130_fd_pr__model__cap_mim
X$134 vdda \$15 sky130_fd_pr__cap_mim_m3_1 l=44.2 w=44.2
* device instance $135 r0 *1 218.45,56.3 res_high_po
X$135 \$15 \$26 vssa sky130_fd_pr__res_high_po l=4.5 w=0.35
* device instance $136 r0 *1 316.36,42.1 res_xhigh_po
X$136 \$17 outp|voutp vssa sky130_fd_pr__res_xhigh_po l=350 w=0.35
* device instance $137 r0 *1 316.36,44.7 res_xhigh_po
X$137 \$17 outn|voutn vssa sky130_fd_pr__res_xhigh_po l=350 w=0.35
.ENDS integrator
