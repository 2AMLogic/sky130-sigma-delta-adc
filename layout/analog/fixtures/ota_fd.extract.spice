* extracted by klt extract --deck sky130

* cell ota_fd
* pin ibias
* pin inn
* pin inp
* pin outn
* pin outp
* pin vcm
* pin vdda
* pin vssa
.SUBCKT ota_fd ibias inn inp outn outp vcm vdda vssa
* device instance $1 r0 *1 6.795,72.47 nfet
X$1 ibias ibias vssa vssa sky130_fd_pr__nfet_01v8 L=0.5 W=2 AS=0.84 AD=0.84
+ PS=4.84 PD=4.84
* device instance $2 r0 *1 12.385,72.47 nfet
X$2 \$5 ibias vssa vssa sky130_fd_pr__nfet_01v8 L=0.5 W=2 AS=0.84 AD=0.84
+ PS=4.84 PD=4.84
* device instance $3 r0 *1 17.975,72.47 nfet
X$3 \$20 ibias vssa vssa sky130_fd_pr__nfet_01v8 L=0.5 W=2 AS=0.84 AD=0.84
+ PS=4.84 PD=4.84
* device instance $4 r0 *1 23.815,71.68 nfet
X$4 \$6 \$6 vssa vssa sky130_fd_pr__nfet_01v8 L=1 W=0.42 AS=0.1764 AD=0.1764
+ PS=1.68 PD=1.68
* device instance $5 r0 *1 36.165,72.47 nfet
X$5 \$11 \$1 \$10 vssa sky130_fd_pr__nfet_01v8 L=0.5 W=2 AS=0.84 AD=0.84
+ PS=4.84 PD=4.84
* device instance $6 r0 *1 37.905,72.47 nfet
X$6 \$7 vcm \$10 vssa sky130_fd_pr__nfet_01v8 L=0.5 W=2 AS=0.84 AD=0.84 PS=4.84
+ PD=4.84
* device instance $7 r0 *1 62.885,72.47 nfet
X$7 \$9 ibias vssa vssa sky130_fd_pr__nfet_01v8 L=0.5 W=2 AS=0.84 AD=0.84
+ PS=4.84 PD=4.84
* device instance $8 r0 *1 64.625,72.47 nfet
X$8 \$13 ibias vssa vssa sky130_fd_pr__nfet_01v8 L=0.5 W=2 AS=0.84 AD=0.84
+ PS=4.84 PD=4.84
* device instance $9 r0 *1 66.365,72.47 nfet
X$9 \$9 ibias vssa vssa sky130_fd_pr__nfet_01v8 L=0.5 W=2 AS=0.84 AD=0.84
+ PS=4.84 PD=4.84
* device instance $10 r0 *1 68.105,72.47 nfet
X$10 \$13 ibias vssa vssa sky130_fd_pr__nfet_01v8 L=0.5 W=2 AS=0.84 AD=0.84
+ PS=4.84 PD=4.84
* device instance $11 r0 *1 69.845,72.47 nfet
X$11 \$9 ibias vssa vssa sky130_fd_pr__nfet_01v8 L=0.5 W=2 AS=0.84 AD=0.84
+ PS=4.84 PD=4.84
* device instance $12 r0 *1 71.585,72.47 nfet
X$12 \$13 ibias vssa vssa sky130_fd_pr__nfet_01v8 L=0.5 W=2 AS=0.84 AD=0.84
+ PS=4.84 PD=4.84
* device instance $13 r0 *1 73.325,72.47 nfet
X$13 \$9 ibias vssa vssa sky130_fd_pr__nfet_01v8 L=0.5 W=2 AS=0.84 AD=0.84
+ PS=4.84 PD=4.84
* device instance $14 r0 *1 75.065,72.47 nfet
X$14 \$13 ibias vssa vssa sky130_fd_pr__nfet_01v8 L=0.5 W=2 AS=0.84 AD=0.84
+ PS=4.84 PD=4.84
* device instance $15 r0 *1 29.655,73.14 nfet
X$15 \$10 ibias vssa vssa sky130_fd_pr__nfet_01v8 L=0.5 W=2 AS=0.84 AD=0.42
+ PS=4.84 PD=2.42
* device instance $16 r0 *1 30.575,73.14 nfet
X$16 vssa ibias \$10 vssa sky130_fd_pr__nfet_01v8 L=0.5 W=2 AS=0.42 AD=0.84
+ PS=2.42 PD=4.84
* device instance $17 r0 *1 36.165,75.99 nfet
X$17 \$7 vcm \$10 vssa sky130_fd_pr__nfet_01v8 L=0.5 W=2 AS=0.84 AD=0.84
+ PS=4.84 PD=4.84
* device instance $18 r0 *1 37.905,75.99 nfet
X$18 \$11 \$1 \$10 vssa sky130_fd_pr__nfet_01v8 L=0.5 W=2 AS=0.84 AD=0.84
+ PS=4.84 PD=4.84
* device instance $19 r0 *1 43.495,73.14 nfet
X$19 \$12 ibias vssa vssa sky130_fd_pr__nfet_01v8 L=0.5 W=2 AS=0.84 AD=0.42
+ PS=4.84 PD=2.42
* device instance $20 r0 *1 44.415,73.14 nfet
X$20 vssa ibias \$12 vssa sky130_fd_pr__nfet_01v8 L=0.5 W=2 AS=0.42 AD=0.42
+ PS=2.42 PD=2.42
* device instance $21 r0 *1 45.335,73.14 nfet
X$21 \$12 ibias vssa vssa sky130_fd_pr__nfet_01v8 L=0.5 W=2 AS=0.42 AD=0.42
+ PS=2.42 PD=2.42
* device instance $22 r0 *1 46.255,73.14 nfet
X$22 vssa ibias \$12 vssa sky130_fd_pr__nfet_01v8 L=0.5 W=2 AS=0.42 AD=0.42
+ PS=2.42 PD=2.42
* device instance $23 r0 *1 47.175,73.14 nfet
X$23 \$12 ibias vssa vssa sky130_fd_pr__nfet_01v8 L=0.5 W=2 AS=0.42 AD=0.42
+ PS=2.42 PD=2.42
* device instance $24 r0 *1 48.095,73.14 nfet
X$24 vssa ibias \$12 vssa sky130_fd_pr__nfet_01v8 L=0.5 W=2 AS=0.42 AD=0.42
+ PS=2.42 PD=2.42
* device instance $25 r0 *1 49.015,73.14 nfet
X$25 \$12 ibias vssa vssa sky130_fd_pr__nfet_01v8 L=0.5 W=2 AS=0.42 AD=0.42
+ PS=2.42 PD=2.42
* device instance $26 r0 *1 49.935,73.14 nfet
X$26 vssa ibias \$12 vssa sky130_fd_pr__nfet_01v8 L=0.5 W=2 AS=0.42 AD=0.42
+ PS=2.42 PD=2.42
* device instance $27 r0 *1 50.855,73.14 nfet
X$27 \$12 ibias vssa vssa sky130_fd_pr__nfet_01v8 L=0.5 W=2 AS=0.42 AD=0.42
+ PS=2.42 PD=2.42
* device instance $28 r0 *1 51.775,73.14 nfet
X$28 vssa ibias \$12 vssa sky130_fd_pr__nfet_01v8 L=0.5 W=2 AS=0.42 AD=0.42
+ PS=2.42 PD=2.42
* device instance $29 r0 *1 52.695,73.14 nfet
X$29 \$12 ibias vssa vssa sky130_fd_pr__nfet_01v8 L=0.5 W=2 AS=0.42 AD=0.42
+ PS=2.42 PD=2.42
* device instance $30 r0 *1 53.615,73.14 nfet
X$30 vssa ibias \$12 vssa sky130_fd_pr__nfet_01v8 L=0.5 W=2 AS=0.42 AD=0.42
+ PS=2.42 PD=2.42
* device instance $31 r0 *1 54.535,73.14 nfet
X$31 \$12 ibias vssa vssa sky130_fd_pr__nfet_01v8 L=0.5 W=2 AS=0.42 AD=0.42
+ PS=2.42 PD=2.42
* device instance $32 r0 *1 55.455,73.14 nfet
X$32 vssa ibias \$12 vssa sky130_fd_pr__nfet_01v8 L=0.5 W=2 AS=0.42 AD=0.42
+ PS=2.42 PD=2.42
* device instance $33 r0 *1 56.375,73.14 nfet
X$33 \$12 ibias vssa vssa sky130_fd_pr__nfet_01v8 L=0.5 W=2 AS=0.42 AD=0.42
+ PS=2.42 PD=2.42
* device instance $34 r0 *1 57.295,73.14 nfet
X$34 vssa ibias \$12 vssa sky130_fd_pr__nfet_01v8 L=0.5 W=2 AS=0.42 AD=0.84
+ PS=2.42 PD=4.84
* device instance $35 r0 *1 62.885,75.99 nfet
X$35 \$13 ibias vssa vssa sky130_fd_pr__nfet_01v8 L=0.5 W=2 AS=0.84 AD=0.84
+ PS=4.84 PD=4.84
* device instance $36 r0 *1 64.625,75.99 nfet
X$36 \$9 ibias vssa vssa sky130_fd_pr__nfet_01v8 L=0.5 W=2 AS=0.84 AD=0.84
+ PS=4.84 PD=4.84
* device instance $37 r0 *1 66.365,75.99 nfet
X$37 \$13 ibias vssa vssa sky130_fd_pr__nfet_01v8 L=0.5 W=2 AS=0.84 AD=0.84
+ PS=4.84 PD=4.84
* device instance $38 r0 *1 68.105,75.99 nfet
X$38 \$9 ibias vssa vssa sky130_fd_pr__nfet_01v8 L=0.5 W=2 AS=0.84 AD=0.84
+ PS=4.84 PD=4.84
* device instance $39 r0 *1 69.845,75.99 nfet
X$39 \$13 ibias vssa vssa sky130_fd_pr__nfet_01v8 L=0.5 W=2 AS=0.84 AD=0.84
+ PS=4.84 PD=4.84
* device instance $40 r0 *1 71.585,75.99 nfet
X$40 \$9 ibias vssa vssa sky130_fd_pr__nfet_01v8 L=0.5 W=2 AS=0.84 AD=0.84
+ PS=4.84 PD=4.84
* device instance $41 r0 *1 73.325,75.99 nfet
X$41 \$13 ibias vssa vssa sky130_fd_pr__nfet_01v8 L=0.5 W=2 AS=0.84 AD=0.84
+ PS=4.84 PD=4.84
* device instance $42 r0 *1 75.065,75.99 nfet
X$42 \$9 ibias vssa vssa sky130_fd_pr__nfet_01v8 L=0.5 W=2 AS=0.84 AD=0.84
+ PS=4.84 PD=4.84
* device instance $43 r0 *1 6.795,102.63 nfet
X$43 \$16 inn \$12 vssa sky130_fd_pr__nfet_01v8 L=0.5 W=8 AS=3.36 AD=3.36
+ PS=16.84 PD=16.84
* device instance $44 r0 *1 6.795,93.11 nfet
X$44 \$15 inp \$12 vssa sky130_fd_pr__nfet_01v8 L=0.5 W=8 AS=3.36 AD=3.36
+ PS=16.84 PD=16.84
* device instance $45 r0 *1 8.535,102.63 nfet
X$45 \$15 inp \$12 vssa sky130_fd_pr__nfet_01v8 L=0.5 W=8 AS=3.36 AD=3.36
+ PS=16.84 PD=16.84
* device instance $46 r0 *1 8.535,93.11 nfet
X$46 \$16 inn \$12 vssa sky130_fd_pr__nfet_01v8 L=0.5 W=8 AS=3.36 AD=3.36
+ PS=16.84 PD=16.84
* device instance $47 r0 *1 16.125,92.61 nfet
X$47 outn \$6 \$9 vssa sky130_fd_pr__nfet_01v8 L=0.5 W=7 AS=2.94 AD=2.94
+ PS=14.84 PD=14.84
* device instance $48 r0 *1 16.125,101.13 nfet
X$48 outp \$6 \$13 vssa sky130_fd_pr__nfet_01v8 L=0.5 W=7 AS=2.94 AD=2.94
+ PS=14.84 PD=14.84
* device instance $49 r0 *1 17.865,101.13 nfet
X$49 outn \$6 \$9 vssa sky130_fd_pr__nfet_01v8 L=0.5 W=7 AS=2.94 AD=2.94
+ PS=14.84 PD=14.84
* device instance $50 r0 *1 17.865,92.61 nfet
X$50 outp \$6 \$13 vssa sky130_fd_pr__nfet_01v8 L=0.5 W=7 AS=2.94 AD=2.94
+ PS=14.84 PD=14.84
* device instance $51 r0 *1 54.21,118.96 pfet
X$51 \$20 \$20 vdda vdda sky130_fd_pr__pfet_01v8 L=0.6 W=0.42 AS=0.1764
+ AD=0.1764 PS=1.68 PD=1.68
* device instance $52 r0 *1 35.5,120 pfet
X$52 \$11 \$11 vdda vdda sky130_fd_pr__pfet_01v8 L=0.5 W=2.5 AS=1.05 AD=1.05
+ PS=5.84 PD=5.84
* device instance $53 r0 *1 37.24,120 pfet
X$53 \$7 \$11 vdda vdda sky130_fd_pr__pfet_01v8 L=0.5 W=2.5 AS=1.05 AD=1.05
+ PS=5.84 PD=5.84
* device instance $54 r0 *1 42.88,121.25 pfet
X$54 \$5 \$5 vdda vdda sky130_fd_pr__pfet_01v8 L=0.5 W=5 AS=2.1 AD=2.1 PS=10.84
+ PD=10.84
* device instance $55 r0 *1 48.52,121.25 pfet
X$55 \$6 \$5 vdda vdda sky130_fd_pr__pfet_01v8 L=0.5 W=5 AS=2.1 AD=2.1 PS=10.84
+ PD=10.84
* device instance $56 r0 *1 35.5,124.02 pfet
X$56 \$7 \$11 vdda vdda sky130_fd_pr__pfet_01v8 L=0.5 W=2.5 AS=1.05 AD=1.05
+ PS=5.84 PD=5.84
* device instance $57 r0 *1 37.24,124.02 pfet
X$57 \$11 \$11 vdda vdda sky130_fd_pr__pfet_01v8 L=0.5 W=2.5 AS=1.05 AD=1.05
+ PS=5.84 PD=5.84
* device instance $58 r0 *1 6.82,123.75 pfet
X$58 \$15 \$7 vdda vdda sky130_fd_pr__pfet_01v8 L=0.5 W=10 AS=4.2 AD=4.2
+ PS=20.84 PD=20.84
* device instance $59 r0 *1 8.56,123.75 pfet
X$59 \$16 \$7 vdda vdda sky130_fd_pr__pfet_01v8 L=0.5 W=10 AS=4.2 AD=4.2
+ PS=20.84 PD=20.84
* device instance $60 r0 *1 10.3,123.75 pfet
X$60 \$15 \$7 vdda vdda sky130_fd_pr__pfet_01v8 L=0.5 W=10 AS=4.2 AD=4.2
+ PS=20.84 PD=20.84
* device instance $61 r0 *1 12.04,123.75 pfet
X$61 \$16 \$7 vdda vdda sky130_fd_pr__pfet_01v8 L=0.5 W=10 AS=4.2 AD=4.2
+ PS=20.84 PD=20.84
* device instance $62 r0 *1 13.78,123.75 pfet
X$62 \$15 \$7 vdda vdda sky130_fd_pr__pfet_01v8 L=0.5 W=10 AS=4.2 AD=4.2
+ PS=20.84 PD=20.84
* device instance $63 r0 *1 15.52,123.75 pfet
X$63 \$16 \$7 vdda vdda sky130_fd_pr__pfet_01v8 L=0.5 W=10 AS=4.2 AD=4.2
+ PS=20.84 PD=20.84
* device instance $64 r0 *1 17.26,123.75 pfet
X$64 \$15 \$7 vdda vdda sky130_fd_pr__pfet_01v8 L=0.5 W=10 AS=4.2 AD=4.2
+ PS=20.84 PD=20.84
* device instance $65 r0 *1 19,123.75 pfet
X$65 \$16 \$7 vdda vdda sky130_fd_pr__pfet_01v8 L=0.5 W=10 AS=4.2 AD=4.2
+ PS=20.84 PD=20.84
* device instance $66 r0 *1 24.64,123.75 pfet
X$66 outn \$20 \$15 vdda sky130_fd_pr__pfet_01v8 L=0.5 W=10 AS=4.2 AD=4.2
+ PS=20.84 PD=20.84
* device instance $67 r0 *1 26.38,123.75 pfet
X$67 outp \$20 \$16 vdda sky130_fd_pr__pfet_01v8 L=0.5 W=10 AS=4.2 AD=4.2
+ PS=20.84 PD=20.84
* device instance $68 r0 *1 28.12,123.75 pfet
X$68 outn \$20 \$15 vdda sky130_fd_pr__pfet_01v8 L=0.5 W=10 AS=4.2 AD=4.2
+ PS=20.84 PD=20.84
* device instance $69 r0 *1 29.86,123.75 pfet
X$69 outp \$20 \$16 vdda sky130_fd_pr__pfet_01v8 L=0.5 W=10 AS=4.2 AD=4.2
+ PS=20.84 PD=20.84
* device instance $70 r0 *1 6.82,135.27 pfet
X$70 \$16 \$7 vdda vdda sky130_fd_pr__pfet_01v8 L=0.5 W=10 AS=4.2 AD=4.2
+ PS=20.84 PD=20.84
* device instance $71 r0 *1 8.56,135.27 pfet
X$71 \$15 \$7 vdda vdda sky130_fd_pr__pfet_01v8 L=0.5 W=10 AS=4.2 AD=4.2
+ PS=20.84 PD=20.84
* device instance $72 r0 *1 10.3,135.27 pfet
X$72 \$16 \$7 vdda vdda sky130_fd_pr__pfet_01v8 L=0.5 W=10 AS=4.2 AD=4.2
+ PS=20.84 PD=20.84
* device instance $73 r0 *1 12.04,135.27 pfet
X$73 \$15 \$7 vdda vdda sky130_fd_pr__pfet_01v8 L=0.5 W=10 AS=4.2 AD=4.2
+ PS=20.84 PD=20.84
* device instance $74 r0 *1 13.78,135.27 pfet
X$74 \$16 \$7 vdda vdda sky130_fd_pr__pfet_01v8 L=0.5 W=10 AS=4.2 AD=4.2
+ PS=20.84 PD=20.84
* device instance $75 r0 *1 15.52,135.27 pfet
X$75 \$15 \$7 vdda vdda sky130_fd_pr__pfet_01v8 L=0.5 W=10 AS=4.2 AD=4.2
+ PS=20.84 PD=20.84
* device instance $76 r0 *1 17.26,135.27 pfet
X$76 \$16 \$7 vdda vdda sky130_fd_pr__pfet_01v8 L=0.5 W=10 AS=4.2 AD=4.2
+ PS=20.84 PD=20.84
* device instance $77 r0 *1 19,135.27 pfet
X$77 \$15 \$7 vdda vdda sky130_fd_pr__pfet_01v8 L=0.5 W=10 AS=4.2 AD=4.2
+ PS=20.84 PD=20.84
* device instance $78 r0 *1 24.64,135.27 pfet
X$78 outp \$20 \$16 vdda sky130_fd_pr__pfet_01v8 L=0.5 W=10 AS=4.2 AD=4.2
+ PS=20.84 PD=20.84
* device instance $79 r0 *1 26.38,135.27 pfet
X$79 outn \$20 \$15 vdda sky130_fd_pr__pfet_01v8 L=0.5 W=10 AS=4.2 AD=4.2
+ PS=20.84 PD=20.84
* device instance $80 r0 *1 28.12,135.27 pfet
X$80 outp \$20 \$16 vdda sky130_fd_pr__pfet_01v8 L=0.5 W=10 AS=4.2 AD=4.2
+ PS=20.84 PD=20.84
* device instance $81 r0 *1 29.86,135.27 pfet
X$81 outn \$20 \$15 vdda sky130_fd_pr__pfet_01v8 L=0.5 W=10 AS=4.2 AD=4.2
+ PS=20.84 PD=20.84
* device instance $82 r0 *1 57.235,18.235 sky130_fd_pr__model__cap_mim
X$82 outp \$1 sky130_fd_pr__cap_mim_m3_1 l=7.07 w=7.07
* device instance $83 r0 *1 66.805,18.235 sky130_fd_pr__model__cap_mim
X$83 outn \$1 sky130_fd_pr__cap_mim_m3_1 l=7.07 w=7.07
* device instance $84 r0 *1 24.6,36.8 sky130_fd_pr__model__cap_mim
X$84 vdda \$2 sky130_fd_pr__cap_mim_m3_1 l=44.2 w=44.2
* device instance $85 r0 *1 79.73,15.5 res_high_po
X$85 \$2 \$7 vssa sky130_fd_pr__res_high_po l=4.5 w=0.35
* device instance $86 r0 *1 177.64,1.3 res_xhigh_po
X$86 \$1 outp vssa sky130_fd_pr__res_xhigh_po l=350 w=0.35
* device instance $87 r0 *1 177.64,3.9 res_xhigh_po
X$87 \$1 outn vssa sky130_fd_pr__res_xhigh_po l=350 w=0.35
.ENDS ota_fd
