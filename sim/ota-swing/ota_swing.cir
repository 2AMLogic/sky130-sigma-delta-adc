* OTA output-swing / gain-compression bench (issue #331) -- circuit
* body for `klt sim` (no .lib/.control/.end: klt sim owns those;
* corner = process/temp/Vdda). Circuit under test:
* design/ota/ota_fd.spice as committed on main, twice -- one instance
* per load. Closed-loop integrate-phase configuration of
* design/ota/SIZING.md with the summing-node load the integrator
* presents in phi2 (driven Cs + parked Cs + Cp + Ci feedback,
* beta = Ci/(Ci+2Cs+Cp)), 1.1 pF external load per side (next
* stage's Cs + output parasitics, SIZING case A). Cell a: Ci = 2 pF
* (main). Cell b: Ci = 3.334 pF (the #257 c0p3 rescale, DR-007,
* parameterised here; it does not depend on that PR merging).
* Boundary (DR-005): vcm = 0.9 V ideal, ibias = 5 uA ideal sink.
* Sequence per amplitude and polarity: reset (ideal switches short
* out<->sum, unity feedback, vod -> 0, plates re-park at vcm), then
* 5 accumulated plate steps (one clock's charge transfer each,
* the way same-decision clocks build integrator swing), then a hold
* past the 97.66 ns phase. vod and the output common mode are read
* at the end of every hold; see make_request.py for the grid.
.include "../../design/ota/ota_fd.spice"
Vdda vdda 0 1.8
Vvcm vcm 0 0.9
Vrst rst 0 PWL(
+  0 1 7.5e-07 1 7.51e-07 0 1.749e-06 0 1.75e-06 1 2e-06 1 2.001e-06 0 2.999e-06 0 3e-06 1 3.25e-06 1 3.251e-06 0 4.249e-06 0 4.25e-06 1 4.5e-06 1 4.501e-06 0 5.499e-06 0 5.5e-06 1 5.75e-06
+  1 5.751e-06 0 6.749e-06 0 6.75e-06 1 7e-06 1 7.001e-06 0 7.999e-06 0 8e-06 1 8.25e-06 1 8.251e-06 0 9.249e-06 0 9.25e-06 1 9.5e-06 1 9.501e-06 0 1.0499e-05 0 1.05e-05 1 1.075e-05 1
+  1.0751e-05 0 1.1749e-05 0 1.175e-05 1 1.2e-05 1 1.2001e-05 0 1.2999e-05 0 1.3e-05 1 1.325e-05 1 1.3251e-05 0 1.4249e-05 0 1.425e-05 1 1.45e-05 1 1.4501e-05 0 1.5499e-05 0 1.55e-05 1
+  1.575e-05 1 1.5751e-05 0 1.6749e-05 0 1.675e-05 1 1.7e-05 1 1.7001e-05 0 1.7999e-05 0 1.8e-05 1 1.825e-05 1 1.8251e-05 0 1.9249e-05 0 1.925e-05 1 1.95e-05 1 1.9501e-05 0 2.0499e-05 0
+  2.05e-05 1 2.075e-05 1 2.0751e-05 0 2.1749e-05 0 2.175e-05 1 2.2e-05 1 2.2001e-05 0 2.2999e-05 0 2.3e-05 1 2.325e-05 1 2.3251e-05 0 2.4249e-05 0 2.425e-05 1 2.45e-05 1 2.4501e-05 0
+  2.5499e-05 0 2.55e-05 1 2.575e-05 1 2.5751e-05 0 2.6749e-05 0 2.675e-05 1 2.7e-05 1 2.7001e-05 0 2.7999e-05 0 2.8e-05 1 2.825e-05 1 2.8251e-05 0 2.9249e-05 0 2.925e-05 1 2.95e-05 1
+  2.9501e-05 0 3.0499e-05 0 3.05e-05 1 3.075e-05 1 3.0751e-05 0 3.1749e-05 0 3.175e-05 1 3.2e-05 1 3.2001e-05 0 3.2999e-05 0 3.3e-05 1 3.325e-05 1 3.3251e-05 0 3.4249e-05 0 3.425e-05 1
+  3.45e-05 1 3.4501e-05 0 3.55e-05 0 )
* --- cell a: main (Ci = 2 pF) ---
* one ibias source per cell: a shared node would halve every leg
* (two diodes on one 5 uA source), and the OTA would run at half bias
Ibiasa vdda ibiasa 5u
Xotaa vdda 0 sumpa sumna outpa outna vcm ibiasa ota_fd
Vspa inpap 0 PWL(
+  0 0.9 5e-07 0.9 8e-07 0.9 8.002e-07 0.92 9.2e-07 0.92 9.202e-07 0.94 1.04e-06 0.94 1.0402e-06 0.96 1.16e-06 0.96 1.1602e-06 0.98 1.28e-06 0.98 1.2802e-06 1 1.75e-06 1 1.7502e-06 0.9
+  2.05e-06 0.9 2.0502e-06 0.88 2.17e-06 0.88 2.1702e-06 0.86 2.29e-06 0.86 2.2902e-06 0.84 2.41e-06 0.84 2.4102e-06 0.82 2.53e-06 0.82 2.5302e-06 0.8 3e-06 0.8 3.0002e-06 0.9 3.3e-06 0.9
+  3.3002e-06 0.94 3.42e-06 0.94 3.4202e-06 0.98 3.54e-06 0.98 3.5402e-06 1.02 3.66e-06 1.02 3.6602e-06 1.06 3.78e-06 1.06 3.7802e-06 1.1 4.25e-06 1.1 4.2502e-06 0.9 4.55e-06 0.9 4.5502e-06
+  0.86 4.67e-06 0.86 4.6702e-06 0.82 4.79e-06 0.82 4.7902e-06 0.78 4.91e-06 0.78 4.9102e-06 0.74 5.03e-06 0.74 5.0302e-06 0.7 5.5e-06 0.7 5.5002e-06 0.9 5.8e-06 0.9 5.8002e-06 0.96 5.92e-06
+  0.96 5.9202e-06 1.02 6.04e-06 1.02 6.0402e-06 1.08 6.16e-06 1.08 6.1602e-06 1.14 6.28e-06 1.14 6.2802e-06 1.2 6.75e-06 1.2 6.7502e-06 0.9 7.05e-06 0.9 7.0502e-06 0.84 7.17e-06 0.84
+  7.1702e-06 0.78 7.29e-06 0.78 7.2902e-06 0.72 7.41e-06 0.72 7.4102e-06 0.66 7.53e-06 0.66 7.5302e-06 0.6 8e-06 0.6 8.0002e-06 0.9 8.3e-06 0.9 8.3002e-06 0.98 8.42e-06 0.98 8.4202e-06 1.06
+  8.54e-06 1.06 8.5402e-06 1.14 8.66e-06 1.14 8.6602e-06 1.22 8.78e-06 1.22 8.7802e-06 1.3 9.25e-06 1.3 9.2502e-06 0.9 9.55e-06 0.9 9.5502e-06 0.82 9.67e-06 0.82 9.6702e-06 0.74 9.79e-06
+  0.74 9.7902e-06 0.66 9.91e-06 0.66 9.9102e-06 0.58 1.003e-05 0.58 1.00302e-05 0.5 1.05e-05 0.5 1.05002e-05 0.9 1.08e-05 0.9 1.08002e-05 1 1.092e-05 1 1.09202e-05 1.1 1.104e-05 1.1
+  1.10402e-05 1.2 1.116e-05 1.2 1.11602e-05 1.3 1.128e-05 1.3 1.12802e-05 1.4 1.175e-05 1.4 1.17502e-05 0.9 1.205e-05 0.9 1.20502e-05 0.8 1.217e-05 0.8 1.21702e-05 0.7 1.229e-05 0.7
+  1.22902e-05 0.6 1.241e-05 0.6 1.24102e-05 0.5 1.253e-05 0.5 1.25302e-05 0.4 1.3e-05 0.4 1.30002e-05 0.9 1.33e-05 0.9 1.33002e-05 1.02 1.342e-05 1.02 1.34202e-05 1.14 1.354e-05 1.14
+  1.35402e-05 1.26 1.366e-05 1.26 1.36602e-05 1.38 1.378e-05 1.38 1.37802e-05 1.5 1.425e-05 1.5 1.42502e-05 0.9 1.455e-05 0.9 1.45502e-05 0.78 1.467e-05 0.78 1.46702e-05 0.66 1.479e-05 0.66
+  1.47902e-05 0.54 1.491e-05 0.54 1.49102e-05 0.42 1.503e-05 0.42 1.50302e-05 0.3 1.55e-05 0.3 1.55002e-05 0.9 1.58e-05 0.9 1.58002e-05 1.04 1.592e-05 1.04 1.59202e-05 1.18 1.604e-05 1.18
+  1.60402e-05 1.32 1.616e-05 1.32 1.61602e-05 1.46 1.628e-05 1.46 1.62802e-05 1.6 1.675e-05 1.6 1.67502e-05 0.9 1.705e-05 0.9 1.70502e-05 0.76 1.717e-05 0.76 1.71702e-05 0.62 1.729e-05 0.62
+  1.72902e-05 0.48 1.741e-05 0.48 1.74102e-05 0.34 1.753e-05 0.34 1.75302e-05 0.2 1.8e-05 0.2 1.80002e-05 0.9 1.83e-05 0.9 1.83002e-05 1.06 1.842e-05 1.06 1.84202e-05 1.22 1.854e-05 1.22
+  1.85402e-05 1.38 1.866e-05 1.38 1.86602e-05 1.54 1.878e-05 1.54 1.87802e-05 1.7 1.925e-05 1.7 1.92502e-05 0.9 1.955e-05 0.9 1.95502e-05 0.74 1.967e-05 0.74 1.96702e-05 0.58 1.979e-05 0.58
+  1.97902e-05 0.42 1.991e-05 0.42 1.99102e-05 0.26 2.003e-05 0.26 2.00302e-05 0.1 2.05e-05 0.1 2.05002e-05 0.9 2.08e-05 0.9 2.08002e-05 1.08 2.092e-05 1.08 2.09202e-05 1.26 2.104e-05 1.26
+  2.10402e-05 1.44 2.116e-05 1.44 2.11602e-05 1.62 2.128e-05 1.62 2.12802e-05 1.8 2.175e-05 1.8 2.17502e-05 0.9 2.205e-05 0.9 2.20502e-05 0.72 2.217e-05 0.72 2.21702e-05 0.54 2.229e-05 0.54
+  2.22902e-05 0.36 2.241e-05 0.36 2.24102e-05 0.18 2.253e-05 0.18 2.25302e-05 0 2.3e-05 0 2.30002e-05 0.9 2.33e-05 0.9 2.33002e-05 1.1 2.342e-05 1.1 2.34202e-05 1.3 2.354e-05 1.3
+  2.35402e-05 1.5 2.366e-05 1.5 2.36602e-05 1.7 2.378e-05 1.7 2.37802e-05 1.9 2.425e-05 1.9 2.42502e-05 0.9 2.455e-05 0.9 2.45502e-05 0.7 2.467e-05 0.7 2.46702e-05 0.5 2.479e-05 0.5
+  2.47902e-05 0.3 2.491e-05 0.3 2.49102e-05 0.1 2.503e-05 0.1 2.50302e-05 -0.1 2.55e-05 -0.1 2.55002e-05 0.9 2.58e-05 0.9 2.58002e-05 1.12 2.592e-05 1.12 2.59202e-05 1.34 2.604e-05 1.34
+  2.60402e-05 1.56 2.616e-05 1.56 2.61602e-05 1.78 2.628e-05 1.78 2.62802e-05 2 2.675e-05 2 2.67502e-05 0.9 2.705e-05 0.9 2.70502e-05 0.68 2.717e-05 0.68 2.71702e-05 0.46 2.729e-05 0.46
+  2.72902e-05 0.24 2.741e-05 0.24 2.74102e-05 0.02 2.753e-05 0.02 2.75302e-05 -0.2 2.8e-05 -0.2 2.80002e-05 0.9 2.83e-05 0.9 2.83002e-05 1.14 2.842e-05 1.14 2.84202e-05 1.38 2.854e-05 1.38
+  2.85402e-05 1.62 2.866e-05 1.62 2.86602e-05 1.86 2.878e-05 1.86 2.87802e-05 2.1 2.925e-05 2.1 2.92502e-05 0.9 2.955e-05 0.9 2.95502e-05 0.66 2.967e-05 0.66 2.96702e-05 0.42 2.979e-05 0.42
+  2.97902e-05 0.18 2.991e-05 0.18 2.99102e-05 -0.06 3.003e-05 -0.06 3.00302e-05 -0.3 3.05e-05 -0.3 3.05002e-05 0.9 3.08e-05 0.9 3.08002e-05 1.16 3.092e-05 1.16 3.09202e-05 1.42 3.104e-05
+  1.42 3.10402e-05 1.68 3.116e-05 1.68 3.11602e-05 1.94 3.128e-05 1.94 3.12802e-05 2.2 3.175e-05 2.2 3.17502e-05 0.9 3.205e-05 0.9 3.20502e-05 0.64 3.217e-05 0.64 3.21702e-05 0.38 3.229e-05
+  0.38 3.22902e-05 0.12 3.241e-05 0.12 3.24102e-05 -0.14 3.253e-05 -0.14 3.25302e-05 -0.4 3.3e-05 -0.4 3.30002e-05 0.9 3.33e-05 0.9 3.33002e-05 1.18 3.342e-05 1.18 3.34202e-05 1.46
+  3.354e-05 1.46 3.35402e-05 1.74 3.366e-05 1.74 3.36602e-05 2.02 3.378e-05 2.02 3.37802e-05 2.3 3.425e-05 2.3 3.42502e-05 0.9 3.455e-05 0.9 3.45502e-05 0.62 3.467e-05 0.62 3.46702e-05 0.34
+  3.479e-05 0.34 3.47902e-05 0.06 3.491e-05 0.06 3.49102e-05 -0.22 3.503e-05 -0.22 3.50302e-05 -0.5 )
Vsna inpan 0 PWL(
+  0 0.9 5e-07 0.9 8e-07 0.9 8.002e-07 0.88 9.2e-07 0.88 9.202e-07 0.86 1.04e-06 0.86 1.0402e-06 0.84 1.16e-06 0.84 1.1602e-06 0.82 1.28e-06 0.82 1.2802e-06 0.8 1.75e-06 0.8 1.7502e-06 0.9
+  2.05e-06 0.9 2.0502e-06 0.92 2.17e-06 0.92 2.1702e-06 0.94 2.29e-06 0.94 2.2902e-06 0.96 2.41e-06 0.96 2.4102e-06 0.98 2.53e-06 0.98 2.5302e-06 1 3e-06 1 3.0002e-06 0.9 3.3e-06 0.9
+  3.3002e-06 0.86 3.42e-06 0.86 3.4202e-06 0.82 3.54e-06 0.82 3.5402e-06 0.78 3.66e-06 0.78 3.6602e-06 0.74 3.78e-06 0.74 3.7802e-06 0.7 4.25e-06 0.7 4.2502e-06 0.9 4.55e-06 0.9 4.5502e-06
+  0.94 4.67e-06 0.94 4.6702e-06 0.98 4.79e-06 0.98 4.7902e-06 1.02 4.91e-06 1.02 4.9102e-06 1.06 5.03e-06 1.06 5.0302e-06 1.1 5.5e-06 1.1 5.5002e-06 0.9 5.8e-06 0.9 5.8002e-06 0.84 5.92e-06
+  0.84 5.9202e-06 0.78 6.04e-06 0.78 6.0402e-06 0.72 6.16e-06 0.72 6.1602e-06 0.66 6.28e-06 0.66 6.2802e-06 0.6 6.75e-06 0.6 6.7502e-06 0.9 7.05e-06 0.9 7.0502e-06 0.96 7.17e-06 0.96
+  7.1702e-06 1.02 7.29e-06 1.02 7.2902e-06 1.08 7.41e-06 1.08 7.4102e-06 1.14 7.53e-06 1.14 7.5302e-06 1.2 8e-06 1.2 8.0002e-06 0.9 8.3e-06 0.9 8.3002e-06 0.82 8.42e-06 0.82 8.4202e-06 0.74
+  8.54e-06 0.74 8.5402e-06 0.66 8.66e-06 0.66 8.6602e-06 0.58 8.78e-06 0.58 8.7802e-06 0.5 9.25e-06 0.5 9.2502e-06 0.9 9.55e-06 0.9 9.5502e-06 0.98 9.67e-06 0.98 9.6702e-06 1.06 9.79e-06
+  1.06 9.7902e-06 1.14 9.91e-06 1.14 9.9102e-06 1.22 1.003e-05 1.22 1.00302e-05 1.3 1.05e-05 1.3 1.05002e-05 0.9 1.08e-05 0.9 1.08002e-05 0.8 1.092e-05 0.8 1.09202e-05 0.7 1.104e-05 0.7
+  1.10402e-05 0.6 1.116e-05 0.6 1.11602e-05 0.5 1.128e-05 0.5 1.12802e-05 0.4 1.175e-05 0.4 1.17502e-05 0.9 1.205e-05 0.9 1.20502e-05 1 1.217e-05 1 1.21702e-05 1.1 1.229e-05 1.1 1.22902e-05
+  1.2 1.241e-05 1.2 1.24102e-05 1.3 1.253e-05 1.3 1.25302e-05 1.4 1.3e-05 1.4 1.30002e-05 0.9 1.33e-05 0.9 1.33002e-05 0.78 1.342e-05 0.78 1.34202e-05 0.66 1.354e-05 0.66 1.35402e-05 0.54
+  1.366e-05 0.54 1.36602e-05 0.42 1.378e-05 0.42 1.37802e-05 0.3 1.425e-05 0.3 1.42502e-05 0.9 1.455e-05 0.9 1.45502e-05 1.02 1.467e-05 1.02 1.46702e-05 1.14 1.479e-05 1.14 1.47902e-05 1.26
+  1.491e-05 1.26 1.49102e-05 1.38 1.503e-05 1.38 1.50302e-05 1.5 1.55e-05 1.5 1.55002e-05 0.9 1.58e-05 0.9 1.58002e-05 0.76 1.592e-05 0.76 1.59202e-05 0.62 1.604e-05 0.62 1.60402e-05 0.48
+  1.616e-05 0.48 1.61602e-05 0.34 1.628e-05 0.34 1.62802e-05 0.2 1.675e-05 0.2 1.67502e-05 0.9 1.705e-05 0.9 1.70502e-05 1.04 1.717e-05 1.04 1.71702e-05 1.18 1.729e-05 1.18 1.72902e-05 1.32
+  1.741e-05 1.32 1.74102e-05 1.46 1.753e-05 1.46 1.75302e-05 1.6 1.8e-05 1.6 1.80002e-05 0.9 1.83e-05 0.9 1.83002e-05 0.74 1.842e-05 0.74 1.84202e-05 0.58 1.854e-05 0.58 1.85402e-05 0.42
+  1.866e-05 0.42 1.86602e-05 0.26 1.878e-05 0.26 1.87802e-05 0.1 1.925e-05 0.1 1.92502e-05 0.9 1.955e-05 0.9 1.95502e-05 1.06 1.967e-05 1.06 1.96702e-05 1.22 1.979e-05 1.22 1.97902e-05 1.38
+  1.991e-05 1.38 1.99102e-05 1.54 2.003e-05 1.54 2.00302e-05 1.7 2.05e-05 1.7 2.05002e-05 0.9 2.08e-05 0.9 2.08002e-05 0.72 2.092e-05 0.72 2.09202e-05 0.54 2.104e-05 0.54 2.10402e-05 0.36
+  2.116e-05 0.36 2.11602e-05 0.18 2.128e-05 0.18 2.12802e-05 0 2.175e-05 0 2.17502e-05 0.9 2.205e-05 0.9 2.20502e-05 1.08 2.217e-05 1.08 2.21702e-05 1.26 2.229e-05 1.26 2.22902e-05 1.44
+  2.241e-05 1.44 2.24102e-05 1.62 2.253e-05 1.62 2.25302e-05 1.8 2.3e-05 1.8 2.30002e-05 0.9 2.33e-05 0.9 2.33002e-05 0.7 2.342e-05 0.7 2.34202e-05 0.5 2.354e-05 0.5 2.35402e-05 0.3
+  2.366e-05 0.3 2.36602e-05 0.1 2.378e-05 0.1 2.37802e-05 -0.1 2.425e-05 -0.1 2.42502e-05 0.9 2.455e-05 0.9 2.45502e-05 1.1 2.467e-05 1.1 2.46702e-05 1.3 2.479e-05 1.3 2.47902e-05 1.5
+  2.491e-05 1.5 2.49102e-05 1.7 2.503e-05 1.7 2.50302e-05 1.9 2.55e-05 1.9 2.55002e-05 0.9 2.58e-05 0.9 2.58002e-05 0.68 2.592e-05 0.68 2.59202e-05 0.46 2.604e-05 0.46 2.60402e-05 0.24
+  2.616e-05 0.24 2.61602e-05 0.02 2.628e-05 0.02 2.62802e-05 -0.2 2.675e-05 -0.2 2.67502e-05 0.9 2.705e-05 0.9 2.70502e-05 1.12 2.717e-05 1.12 2.71702e-05 1.34 2.729e-05 1.34 2.72902e-05
+  1.56 2.741e-05 1.56 2.74102e-05 1.78 2.753e-05 1.78 2.75302e-05 2 2.8e-05 2 2.80002e-05 0.9 2.83e-05 0.9 2.83002e-05 0.66 2.842e-05 0.66 2.84202e-05 0.42 2.854e-05 0.42 2.85402e-05 0.18
+  2.866e-05 0.18 2.86602e-05 -0.06 2.878e-05 -0.06 2.87802e-05 -0.3 2.925e-05 -0.3 2.92502e-05 0.9 2.955e-05 0.9 2.95502e-05 1.14 2.967e-05 1.14 2.96702e-05 1.38 2.979e-05 1.38 2.97902e-05
+  1.62 2.991e-05 1.62 2.99102e-05 1.86 3.003e-05 1.86 3.00302e-05 2.1 3.05e-05 2.1 3.05002e-05 0.9 3.08e-05 0.9 3.08002e-05 0.64 3.092e-05 0.64 3.09202e-05 0.38 3.104e-05 0.38 3.10402e-05
+  0.12 3.116e-05 0.12 3.11602e-05 -0.14 3.128e-05 -0.14 3.12802e-05 -0.4 3.175e-05 -0.4 3.17502e-05 0.9 3.205e-05 0.9 3.20502e-05 1.16 3.217e-05 1.16 3.21702e-05 1.42 3.229e-05 1.42
+  3.22902e-05 1.68 3.241e-05 1.68 3.24102e-05 1.94 3.253e-05 1.94 3.25302e-05 2.2 3.3e-05 2.2 3.30002e-05 0.9 3.33e-05 0.9 3.33002e-05 0.62 3.342e-05 0.62 3.34202e-05 0.34 3.354e-05 0.34
+  3.35402e-05 0.06 3.366e-05 0.06 3.36602e-05 -0.22 3.378e-05 -0.22 3.37802e-05 -0.5 3.425e-05 -0.5 3.42502e-05 0.9 3.455e-05 0.9 3.45502e-05 1.18 3.467e-05 1.18 3.46702e-05 1.46 3.479e-05
+  1.46 3.47902e-05 1.74 3.491e-05 1.74 3.49102e-05 2.02 3.503e-05 2.02 3.50302e-05 2.3 )
Cspa inpap sumpa 1p
Csna inpan sumna 1p
Cdpa sumpa vcm 1p
Cdna sumna vcm 1p
Cipa sumpa outna 2p
Cina sumna outpa 2p
Cppa sumpa 0 35f
Cpna sumna 0 35f
Clpa outpa 0 1.1p
Clna outna 0 1.1p
Srpa outna sumpa rst 0 swr
Srna outpa sumna rst 0 swr
Bvoda voda 0 V='v(outpa)-v(outna)'
Bocma ocma 0 V='0.5*(v(outpa)+v(outna))'
* --- cell b: c0p3 (Ci = 3.334 pF) ---
* one ibias source per cell: a shared node would halve every leg
* (two diodes on one 5 uA source), and the OTA would run at half bias
Ibiasb vdda ibiasb 5u
Xotab vdda 0 sumpb sumnb outpb outnb vcm ibiasb ota_fd
Vspb inpbp 0 PWL(
+  0 0.9 5e-07 0.9 8e-07 0.9 8.002e-07 0.93334 9.2e-07 0.93334 9.202e-07 0.96668 1.04e-06 0.96668 1.0402e-06 1.00002 1.16e-06 1.00002 1.1602e-06 1.03336 1.28e-06 1.03336 1.2802e-06 1.0667
+  1.75e-06 1.0667 1.7502e-06 0.9 2.05e-06 0.9 2.0502e-06 0.86666 2.17e-06 0.86666 2.1702e-06 0.83332 2.29e-06 0.83332 2.2902e-06 0.79998 2.41e-06 0.79998 2.4102e-06 0.76664 2.53e-06 0.76664
+  2.5302e-06 0.7333 3e-06 0.7333 3.0002e-06 0.9 3.3e-06 0.9 3.3002e-06 0.96668 3.42e-06 0.96668 3.4202e-06 1.03336 3.54e-06 1.03336 3.5402e-06 1.10004 3.66e-06 1.10004 3.6602e-06 1.16672
+  3.78e-06 1.16672 3.7802e-06 1.2334 4.25e-06 1.2334 4.2502e-06 0.9 4.55e-06 0.9 4.5502e-06 0.83332 4.67e-06 0.83332 4.6702e-06 0.76664 4.79e-06 0.76664 4.7902e-06 0.69996 4.91e-06 0.69996
+  4.9102e-06 0.63328 5.03e-06 0.63328 5.0302e-06 0.5666 5.5e-06 0.5666 5.5002e-06 0.9 5.8e-06 0.9 5.8002e-06 1.00002 5.92e-06 1.00002 5.9202e-06 1.10004 6.04e-06 1.10004 6.0402e-06 1.20006
+  6.16e-06 1.20006 6.1602e-06 1.30008 6.28e-06 1.30008 6.2802e-06 1.4001 6.75e-06 1.4001 6.7502e-06 0.9 7.05e-06 0.9 7.0502e-06 0.79998 7.17e-06 0.79998 7.1702e-06 0.69996 7.29e-06 0.69996
+  7.2902e-06 0.59994 7.41e-06 0.59994 7.4102e-06 0.49992 7.53e-06 0.49992 7.5302e-06 0.3999 8e-06 0.3999 8.0002e-06 0.9 8.3e-06 0.9 8.3002e-06 1.03336 8.42e-06 1.03336 8.4202e-06 1.16672
+  8.54e-06 1.16672 8.5402e-06 1.30008 8.66e-06 1.30008 8.6602e-06 1.43344 8.78e-06 1.43344 8.7802e-06 1.5668 9.25e-06 1.5668 9.2502e-06 0.9 9.55e-06 0.9 9.5502e-06 0.76664 9.67e-06 0.76664
+  9.6702e-06 0.63328 9.79e-06 0.63328 9.7902e-06 0.49992 9.91e-06 0.49992 9.9102e-06 0.36656 1.003e-05 0.36656 1.00302e-05 0.2332 1.05e-05 0.2332 1.05002e-05 0.9 1.08e-05 0.9 1.08002e-05
+  1.0667 1.092e-05 1.0667 1.09202e-05 1.2334 1.104e-05 1.2334 1.10402e-05 1.4001 1.116e-05 1.4001 1.11602e-05 1.5668 1.128e-05 1.5668 1.12802e-05 1.7335 1.175e-05 1.7335 1.17502e-05 0.9
+  1.205e-05 0.9 1.20502e-05 0.7333 1.217e-05 0.7333 1.21702e-05 0.5666 1.229e-05 0.5666 1.22902e-05 0.3999 1.241e-05 0.3999 1.24102e-05 0.2332 1.253e-05 0.2332 1.25302e-05 0.0665 1.3e-05
+  0.0665 1.30002e-05 0.9 1.33e-05 0.9 1.33002e-05 1.10004 1.342e-05 1.10004 1.34202e-05 1.30008 1.354e-05 1.30008 1.35402e-05 1.50012 1.366e-05 1.50012 1.36602e-05 1.70016 1.378e-05 1.70016
+  1.37802e-05 1.9002 1.425e-05 1.9002 1.42502e-05 0.9 1.455e-05 0.9 1.45502e-05 0.69996 1.467e-05 0.69996 1.46702e-05 0.49992 1.479e-05 0.49992 1.47902e-05 0.29988 1.491e-05 0.29988
+  1.49102e-05 0.09984 1.503e-05 0.09984 1.50302e-05 -0.1002 1.55e-05 -0.1002 1.55002e-05 0.9 1.58e-05 0.9 1.58002e-05 1.13338 1.592e-05 1.13338 1.59202e-05 1.36676 1.604e-05 1.36676
+  1.60402e-05 1.60014 1.616e-05 1.60014 1.61602e-05 1.83352 1.628e-05 1.83352 1.62802e-05 2.0669 1.675e-05 2.0669 1.67502e-05 0.9 1.705e-05 0.9 1.70502e-05 0.66662 1.717e-05 0.66662
+  1.71702e-05 0.43324 1.729e-05 0.43324 1.72902e-05 0.19986 1.741e-05 0.19986 1.74102e-05 -0.03352 1.753e-05 -0.03352 1.75302e-05 -0.2669 1.8e-05 -0.2669 1.80002e-05 0.9 1.83e-05 0.9
+  1.83002e-05 1.16672 1.842e-05 1.16672 1.84202e-05 1.43344 1.854e-05 1.43344 1.85402e-05 1.70016 1.866e-05 1.70016 1.86602e-05 1.96688 1.878e-05 1.96688 1.87802e-05 2.2336 1.925e-05 2.2336
+  1.92502e-05 0.9 1.955e-05 0.9 1.95502e-05 0.63328 1.967e-05 0.63328 1.96702e-05 0.36656 1.979e-05 0.36656 1.97902e-05 0.09984 1.991e-05 0.09984 1.99102e-05 -0.16688 2.003e-05 -0.16688
+  2.00302e-05 -0.4336 2.05e-05 -0.4336 2.05002e-05 0.9 2.08e-05 0.9 2.08002e-05 1.20006 2.092e-05 1.20006 2.09202e-05 1.50012 2.104e-05 1.50012 2.10402e-05 1.80018 2.116e-05 1.80018
+  2.11602e-05 2.10024 2.128e-05 2.10024 2.12802e-05 2.4003 2.175e-05 2.4003 2.17502e-05 0.9 2.205e-05 0.9 2.20502e-05 0.59994 2.217e-05 0.59994 2.21702e-05 0.29988 2.229e-05 0.29988
+  2.22902e-05 -0.00018 2.241e-05 -0.00018 2.24102e-05 -0.30024 2.253e-05 -0.30024 2.25302e-05 -0.6003 2.3e-05 -0.6003 2.30002e-05 0.9 2.33e-05 0.9 2.33002e-05 1.2334 2.342e-05 1.2334
+  2.34202e-05 1.5668 2.354e-05 1.5668 2.35402e-05 1.9002 2.366e-05 1.9002 2.36602e-05 2.2336 2.378e-05 2.2336 2.37802e-05 2.567 2.425e-05 2.567 2.42502e-05 0.9 2.455e-05 0.9 2.45502e-05
+  0.5666 2.467e-05 0.5666 2.46702e-05 0.2332 2.479e-05 0.2332 2.47902e-05 -0.1002 2.491e-05 -0.1002 2.49102e-05 -0.4336 2.503e-05 -0.4336 2.50302e-05 -0.767 2.55e-05 -0.767 2.55002e-05 0.9
+  2.58e-05 0.9 2.58002e-05 1.26674 2.592e-05 1.26674 2.59202e-05 1.63348 2.604e-05 1.63348 2.60402e-05 2.00022 2.616e-05 2.00022 2.61602e-05 2.36696 2.628e-05 2.36696 2.62802e-05 2.7337
+  2.675e-05 2.7337 2.67502e-05 0.9 2.705e-05 0.9 2.70502e-05 0.53326 2.717e-05 0.53326 2.71702e-05 0.16652 2.729e-05 0.16652 2.72902e-05 -0.20022 2.741e-05 -0.20022 2.74102e-05 -0.56696
+  2.753e-05 -0.56696 2.75302e-05 -0.9337 2.8e-05 -0.9337 2.80002e-05 0.9 2.83e-05 0.9 2.83002e-05 1.30008 2.842e-05 1.30008 2.84202e-05 1.70016 2.854e-05 1.70016 2.85402e-05 2.10024
+  2.866e-05 2.10024 2.86602e-05 2.50032 2.878e-05 2.50032 2.87802e-05 2.9004 2.925e-05 2.9004 2.92502e-05 0.9 2.955e-05 0.9 2.95502e-05 0.49992 2.967e-05 0.49992 2.96702e-05 0.09984
+  2.979e-05 0.09984 2.97902e-05 -0.30024 2.991e-05 -0.30024 2.99102e-05 -0.70032 3.003e-05 -0.70032 3.00302e-05 -1.1004 3.05e-05 -1.1004 3.05002e-05 0.9 3.08e-05 0.9 3.08002e-05 1.33342
+  3.092e-05 1.33342 3.09202e-05 1.76684 3.104e-05 1.76684 3.10402e-05 2.20026 3.116e-05 2.20026 3.11602e-05 2.63368 3.128e-05 2.63368 3.12802e-05 3.0671 3.175e-05 3.0671 3.17502e-05 0.9
+  3.205e-05 0.9 3.20502e-05 0.46658 3.217e-05 0.46658 3.21702e-05 0.03316 3.229e-05 0.03316 3.22902e-05 -0.40026 3.241e-05 -0.40026 3.24102e-05 -0.83368 3.253e-05 -0.83368 3.25302e-05
+  -1.2671 3.3e-05 -1.2671 3.30002e-05 0.9 3.33e-05 0.9 3.33002e-05 1.36676 3.342e-05 1.36676 3.34202e-05 1.83352 3.354e-05 1.83352 3.35402e-05 2.30028 3.366e-05 2.30028 3.36602e-05 2.76704
+  3.378e-05 2.76704 3.37802e-05 3.2338 3.425e-05 3.2338 3.42502e-05 0.9 3.455e-05 0.9 3.45502e-05 0.43324 3.467e-05 0.43324 3.46702e-05 -0.03352 3.479e-05 -0.03352 3.47902e-05 -0.50028
+  3.491e-05 -0.50028 3.49102e-05 -0.96704 3.503e-05 -0.96704 3.50302e-05 -1.4338 )
Vsnb inpbn 0 PWL(
+  0 0.9 5e-07 0.9 8e-07 0.9 8.002e-07 0.86666 9.2e-07 0.86666 9.202e-07 0.83332 1.04e-06 0.83332 1.0402e-06 0.79998 1.16e-06 0.79998 1.1602e-06 0.76664 1.28e-06 0.76664 1.2802e-06 0.7333
+  1.75e-06 0.7333 1.7502e-06 0.9 2.05e-06 0.9 2.0502e-06 0.93334 2.17e-06 0.93334 2.1702e-06 0.96668 2.29e-06 0.96668 2.2902e-06 1.00002 2.41e-06 1.00002 2.4102e-06 1.03336 2.53e-06 1.03336
+  2.5302e-06 1.0667 3e-06 1.0667 3.0002e-06 0.9 3.3e-06 0.9 3.3002e-06 0.83332 3.42e-06 0.83332 3.4202e-06 0.76664 3.54e-06 0.76664 3.5402e-06 0.69996 3.66e-06 0.69996 3.6602e-06 0.63328
+  3.78e-06 0.63328 3.7802e-06 0.5666 4.25e-06 0.5666 4.2502e-06 0.9 4.55e-06 0.9 4.5502e-06 0.96668 4.67e-06 0.96668 4.6702e-06 1.03336 4.79e-06 1.03336 4.7902e-06 1.10004 4.91e-06 1.10004
+  4.9102e-06 1.16672 5.03e-06 1.16672 5.0302e-06 1.2334 5.5e-06 1.2334 5.5002e-06 0.9 5.8e-06 0.9 5.8002e-06 0.79998 5.92e-06 0.79998 5.9202e-06 0.69996 6.04e-06 0.69996 6.0402e-06 0.59994
+  6.16e-06 0.59994 6.1602e-06 0.49992 6.28e-06 0.49992 6.2802e-06 0.3999 6.75e-06 0.3999 6.7502e-06 0.9 7.05e-06 0.9 7.0502e-06 1.00002 7.17e-06 1.00002 7.1702e-06 1.10004 7.29e-06 1.10004
+  7.2902e-06 1.20006 7.41e-06 1.20006 7.4102e-06 1.30008 7.53e-06 1.30008 7.5302e-06 1.4001 8e-06 1.4001 8.0002e-06 0.9 8.3e-06 0.9 8.3002e-06 0.76664 8.42e-06 0.76664 8.4202e-06 0.63328
+  8.54e-06 0.63328 8.5402e-06 0.49992 8.66e-06 0.49992 8.6602e-06 0.36656 8.78e-06 0.36656 8.7802e-06 0.2332 9.25e-06 0.2332 9.2502e-06 0.9 9.55e-06 0.9 9.5502e-06 1.03336 9.67e-06 1.03336
+  9.6702e-06 1.16672 9.79e-06 1.16672 9.7902e-06 1.30008 9.91e-06 1.30008 9.9102e-06 1.43344 1.003e-05 1.43344 1.00302e-05 1.5668 1.05e-05 1.5668 1.05002e-05 0.9 1.08e-05 0.9 1.08002e-05
+  0.7333 1.092e-05 0.7333 1.09202e-05 0.5666 1.104e-05 0.5666 1.10402e-05 0.3999 1.116e-05 0.3999 1.11602e-05 0.2332 1.128e-05 0.2332 1.12802e-05 0.0665 1.175e-05 0.0665 1.17502e-05 0.9
+  1.205e-05 0.9 1.20502e-05 1.0667 1.217e-05 1.0667 1.21702e-05 1.2334 1.229e-05 1.2334 1.22902e-05 1.4001 1.241e-05 1.4001 1.24102e-05 1.5668 1.253e-05 1.5668 1.25302e-05 1.7335 1.3e-05
+  1.7335 1.30002e-05 0.9 1.33e-05 0.9 1.33002e-05 0.69996 1.342e-05 0.69996 1.34202e-05 0.49992 1.354e-05 0.49992 1.35402e-05 0.29988 1.366e-05 0.29988 1.36602e-05 0.09984 1.378e-05 0.09984
+  1.37802e-05 -0.1002 1.425e-05 -0.1002 1.42502e-05 0.9 1.455e-05 0.9 1.45502e-05 1.10004 1.467e-05 1.10004 1.46702e-05 1.30008 1.479e-05 1.30008 1.47902e-05 1.50012 1.491e-05 1.50012
+  1.49102e-05 1.70016 1.503e-05 1.70016 1.50302e-05 1.9002 1.55e-05 1.9002 1.55002e-05 0.9 1.58e-05 0.9 1.58002e-05 0.66662 1.592e-05 0.66662 1.59202e-05 0.43324 1.604e-05 0.43324
+  1.60402e-05 0.19986 1.616e-05 0.19986 1.61602e-05 -0.03352 1.628e-05 -0.03352 1.62802e-05 -0.2669 1.675e-05 -0.2669 1.67502e-05 0.9 1.705e-05 0.9 1.70502e-05 1.13338 1.717e-05 1.13338
+  1.71702e-05 1.36676 1.729e-05 1.36676 1.72902e-05 1.60014 1.741e-05 1.60014 1.74102e-05 1.83352 1.753e-05 1.83352 1.75302e-05 2.0669 1.8e-05 2.0669 1.80002e-05 0.9 1.83e-05 0.9
+  1.83002e-05 0.63328 1.842e-05 0.63328 1.84202e-05 0.36656 1.854e-05 0.36656 1.85402e-05 0.09984 1.866e-05 0.09984 1.86602e-05 -0.16688 1.878e-05 -0.16688 1.87802e-05 -0.4336 1.925e-05
+  -0.4336 1.92502e-05 0.9 1.955e-05 0.9 1.95502e-05 1.16672 1.967e-05 1.16672 1.96702e-05 1.43344 1.979e-05 1.43344 1.97902e-05 1.70016 1.991e-05 1.70016 1.99102e-05 1.96688 2.003e-05
+  1.96688 2.00302e-05 2.2336 2.05e-05 2.2336 2.05002e-05 0.9 2.08e-05 0.9 2.08002e-05 0.59994 2.092e-05 0.59994 2.09202e-05 0.29988 2.104e-05 0.29988 2.10402e-05 -0.00018 2.116e-05 -0.00018
+  2.11602e-05 -0.30024 2.128e-05 -0.30024 2.12802e-05 -0.6003 2.175e-05 -0.6003 2.17502e-05 0.9 2.205e-05 0.9 2.20502e-05 1.20006 2.217e-05 1.20006 2.21702e-05 1.50012 2.229e-05 1.50012
+  2.22902e-05 1.80018 2.241e-05 1.80018 2.24102e-05 2.10024 2.253e-05 2.10024 2.25302e-05 2.4003 2.3e-05 2.4003 2.30002e-05 0.9 2.33e-05 0.9 2.33002e-05 0.5666 2.342e-05 0.5666 2.34202e-05
+  0.2332 2.354e-05 0.2332 2.35402e-05 -0.1002 2.366e-05 -0.1002 2.36602e-05 -0.4336 2.378e-05 -0.4336 2.37802e-05 -0.767 2.425e-05 -0.767 2.42502e-05 0.9 2.455e-05 0.9 2.45502e-05 1.2334
+  2.467e-05 1.2334 2.46702e-05 1.5668 2.479e-05 1.5668 2.47902e-05 1.9002 2.491e-05 1.9002 2.49102e-05 2.2336 2.503e-05 2.2336 2.50302e-05 2.567 2.55e-05 2.567 2.55002e-05 0.9 2.58e-05 0.9
+  2.58002e-05 0.53326 2.592e-05 0.53326 2.59202e-05 0.16652 2.604e-05 0.16652 2.60402e-05 -0.20022 2.616e-05 -0.20022 2.61602e-05 -0.56696 2.628e-05 -0.56696 2.62802e-05 -0.9337 2.675e-05
+  -0.9337 2.67502e-05 0.9 2.705e-05 0.9 2.70502e-05 1.26674 2.717e-05 1.26674 2.71702e-05 1.63348 2.729e-05 1.63348 2.72902e-05 2.00022 2.741e-05 2.00022 2.74102e-05 2.36696 2.753e-05
+  2.36696 2.75302e-05 2.7337 2.8e-05 2.7337 2.80002e-05 0.9 2.83e-05 0.9 2.83002e-05 0.49992 2.842e-05 0.49992 2.84202e-05 0.09984 2.854e-05 0.09984 2.85402e-05 -0.30024 2.866e-05 -0.30024
+  2.86602e-05 -0.70032 2.878e-05 -0.70032 2.87802e-05 -1.1004 2.925e-05 -1.1004 2.92502e-05 0.9 2.955e-05 0.9 2.95502e-05 1.30008 2.967e-05 1.30008 2.96702e-05 1.70016 2.979e-05 1.70016
+  2.97902e-05 2.10024 2.991e-05 2.10024 2.99102e-05 2.50032 3.003e-05 2.50032 3.00302e-05 2.9004 3.05e-05 2.9004 3.05002e-05 0.9 3.08e-05 0.9 3.08002e-05 0.46658 3.092e-05 0.46658
+  3.09202e-05 0.03316 3.104e-05 0.03316 3.10402e-05 -0.40026 3.116e-05 -0.40026 3.11602e-05 -0.83368 3.128e-05 -0.83368 3.12802e-05 -1.2671 3.175e-05 -1.2671 3.17502e-05 0.9 3.205e-05 0.9
+  3.20502e-05 1.33342 3.217e-05 1.33342 3.21702e-05 1.76684 3.229e-05 1.76684 3.22902e-05 2.20026 3.241e-05 2.20026 3.24102e-05 2.63368 3.253e-05 2.63368 3.25302e-05 3.0671 3.3e-05 3.0671
+  3.30002e-05 0.9 3.33e-05 0.9 3.33002e-05 0.43324 3.342e-05 0.43324 3.34202e-05 -0.03352 3.354e-05 -0.03352 3.35402e-05 -0.50028 3.366e-05 -0.50028 3.36602e-05 -0.96704 3.378e-05 -0.96704
+  3.37802e-05 -1.4338 3.425e-05 -1.4338 3.42502e-05 0.9 3.455e-05 0.9 3.45502e-05 1.36676 3.467e-05 1.36676 3.46702e-05 1.83352 3.479e-05 1.83352 3.47902e-05 2.30028 3.491e-05 2.30028
+  3.49102e-05 2.76704 3.503e-05 2.76704 3.50302e-05 3.2338 )
Cspb inpbp sumpb 1p
Csnb inpbn sumnb 1p
Cdpb sumpb vcm 1p
Cdnb sumnb vcm 1p
Cipb sumpb outnb 3.334p
Cinb sumnb outpb 3.334p
Cppb sumpb 0 35f
Cpnb sumnb 0 35f
Clpb outpb 0 1.1p
Clnb outnb 0 1.1p
Srpb outnb sumpb rst 0 swr
Srnb outpb sumnb rst 0 swr
Bvodb vodb 0 V='v(outpb)-v(outnb)'
Bocmb ocmb 0 V='0.5*(v(outpb)+v(outnb))'
.model swr sw vt=0.5 vh=0.1 ron=1 roff=1e15
