** sch_path: /home/ubuntu/GitHub/sky130-sigma-delta-adc/.loom/worktrees/issue-41/design/clkgen/clkgen.sch
.subckt clkgen vdda vssa clk phi1 phi1b phi1e phi2
*.iopin vdda
*.iopin vssa
*.ipin clk
*.opin phi1
*.opin phi1b
*.opin phi1e
*.opin phi2
XIckb_n clkb clk vssa vssa sky130_fd_pr__nfet_01v8 L=0.15 W=1 nf=1 ad=0.29 as=0.29 pd=2.58 ps=2.58
+ nrd=0.29 nrs=0.29 sa=0 sb=0 sd=0 mult=1 m=1
XIckb_p vdda clk clkb vdda sky130_fd_pr__pfet_01v8 L=0.15 W=2 nf=1 ad=0.58 as=0.58 pd=4.58 ps=4.58
+ nrd=0.145 nrs=0.145 sa=0 sb=0 sd=0 mult=1 m=1
XNcore1_na core1 clkb vssa vssa sky130_fd_pr__nfet_01v8 L=0.15 W=1 nf=1 ad=0.29 as=0.29 pd=2.58
+ ps=2.58 nrd=0.29 nrs=0.29 sa=0 sb=0 sd=0 mult=1 m=1
XNcore1_nb core1 p2d vssa vssa sky130_fd_pr__nfet_01v8 L=0.15 W=1 nf=1 ad=0.29 as=0.29 pd=2.58
+ ps=2.58 nrd=0.29 nrs=0.29 sa=0 sb=0 sd=0 mult=1 m=1
XNcore1_pa vdda clkb Ncore1_m vdda sky130_fd_pr__pfet_01v8 L=0.15 W=4 nf=1 ad=1.16 as=1.16 pd=8.58
+ ps=8.58 nrd=0.0725 nrs=0.0725 sa=0 sb=0 sd=0 mult=1 m=1
XNcore1_pb Ncore1_m p2d core1 vdda sky130_fd_pr__pfet_01v8 L=0.15 W=4 nf=1 ad=1.16 as=1.16 pd=8.58
+ ps=8.58 nrd=0.0725 nrs=0.0725 sa=0 sb=0 sd=0 mult=1 m=1
XIe1_n e1 core1 vssa vssa sky130_fd_pr__nfet_01v8 L=0.15 W=2 nf=1 ad=0.58 as=0.58 pd=4.58 ps=4.58
+ nrd=0.145 nrs=0.145 sa=0 sb=0 sd=0 mult=1 m=1
XIe1_p vdda core1 e1 vdda sky130_fd_pr__pfet_01v8 L=0.15 W=4 nf=1 ad=1.16 as=1.16 pd=8.58 ps=8.58
+ nrd=0.0725 nrs=0.0725 sa=0 sb=0 sd=0 mult=1 m=1
XIphi1e_n phi1e e1 vssa vssa sky130_fd_pr__nfet_01v8 L=0.15 W=6 nf=1 ad=1.74 as=1.74 pd=12.58
+ ps=12.58 nrd=0.0483333 nrs=0.0483333 sa=0 sb=0 sd=0 mult=2 m=2
XIphi1e_p vdda e1 phi1e vdda sky130_fd_pr__pfet_01v8 L=0.15 W=12 nf=1 ad=3.48 as=3.48 pd=24.58
+ ps=24.58 nrd=0.0241667 nrs=0.0241667 sa=0 sb=0 sd=0 mult=2 m=2
XId1_0_n d1_0 core1 vssa vssa sky130_fd_pr__nfet_01v8 L=0.5 W=1 nf=1 ad=0.29 as=0.29 pd=2.58 ps=2.58
+ nrd=0.29 nrs=0.29 sa=0 sb=0 sd=0 mult=1 m=1
XId1_0_p vdda core1 d1_0 vdda sky130_fd_pr__pfet_01v8 L=0.5 W=2 nf=1 ad=0.58 as=0.58 pd=4.58 ps=4.58
+ nrd=0.145 nrs=0.145 sa=0 sb=0 sd=0 mult=1 m=1
XId1_1_n d1_1 d1_0 vssa vssa sky130_fd_pr__nfet_01v8 L=0.5 W=1 nf=1 ad=0.29 as=0.29 pd=2.58 ps=2.58
+ nrd=0.29 nrs=0.29 sa=0 sb=0 sd=0 mult=1 m=1
XId1_1_p vdda d1_0 d1_1 vdda sky130_fd_pr__pfet_01v8 L=0.5 W=2 nf=1 ad=0.58 as=0.58 pd=4.58 ps=4.58
+ nrd=0.145 nrs=0.145 sa=0 sb=0 sd=0 mult=1 m=1
XId1_2_n d1_2 d1_1 vssa vssa sky130_fd_pr__nfet_01v8 L=0.5 W=1 nf=1 ad=0.29 as=0.29 pd=2.58 ps=2.58
+ nrd=0.29 nrs=0.29 sa=0 sb=0 sd=0 mult=1 m=1
XId1_2_p vdda d1_1 d1_2 vdda sky130_fd_pr__pfet_01v8 L=0.5 W=2 nf=1 ad=0.58 as=0.58 pd=4.58 ps=4.58
+ nrd=0.145 nrs=0.145 sa=0 sb=0 sd=0 mult=1 m=1
XId1_3_n d1_3 d1_2 vssa vssa sky130_fd_pr__nfet_01v8 L=0.5 W=1 nf=1 ad=0.29 as=0.29 pd=2.58 ps=2.58
+ nrd=0.29 nrs=0.29 sa=0 sb=0 sd=0 mult=1 m=1
XId1_3_p vdda d1_2 d1_3 vdda sky130_fd_pr__pfet_01v8 L=0.5 W=2 nf=1 ad=0.58 as=0.58 pd=4.58 ps=4.58
+ nrd=0.145 nrs=0.145 sa=0 sb=0 sd=0 mult=1 m=1
XNphi1_na n1 core1 vssa vssa sky130_fd_pr__nfet_01v8 L=0.15 W=2 nf=1 ad=0.58 as=0.58 pd=4.58 ps=4.58
+ nrd=0.145 nrs=0.145 sa=0 sb=0 sd=0 mult=1 m=1
XNphi1_nb n1 d1_3 vssa vssa sky130_fd_pr__nfet_01v8 L=0.15 W=2 nf=1 ad=0.58 as=0.58 pd=4.58 ps=4.58
+ nrd=0.145 nrs=0.145 sa=0 sb=0 sd=0 mult=1 m=1
XNphi1_pa vdda core1 Nphi1_m vdda sky130_fd_pr__pfet_01v8 L=0.15 W=8 nf=1 ad=2.32 as=2.32 pd=16.58
+ ps=16.58 nrd=0.03625 nrs=0.03625 sa=0 sb=0 sd=0 mult=1 m=1
XNphi1_pb Nphi1_m d1_3 n1 vdda sky130_fd_pr__pfet_01v8 L=0.15 W=8 nf=1 ad=2.32 as=2.32 pd=16.58
+ ps=16.58 nrd=0.03625 nrs=0.03625 sa=0 sb=0 sd=0 mult=1 m=1
XIphi1_n phi1 n1 vssa vssa sky130_fd_pr__nfet_01v8 L=0.15 W=6 nf=1 ad=1.74 as=1.74 pd=12.58 ps=12.58
+ nrd=0.0483333 nrs=0.0483333 sa=0 sb=0 sd=0 mult=2 m=2
XIphi1_p vdda n1 phi1 vdda sky130_fd_pr__pfet_01v8 L=0.15 W=12 nf=1 ad=3.48 as=3.48 pd=24.58
+ ps=24.58 nrd=0.0241667 nrs=0.0241667 sa=0 sb=0 sd=0 mult=2 m=2
XIphi1b_n phi1b phi1 vssa vssa sky130_fd_pr__nfet_01v8 L=0.15 W=6 nf=1 ad=1.74 as=1.74 pd=12.58
+ ps=12.58 nrd=0.0483333 nrs=0.0483333 sa=0 sb=0 sd=0 mult=3 m=3
XIphi1b_p vdda phi1 phi1b vdda sky130_fd_pr__pfet_01v8 L=0.15 W=12 nf=1 ad=3.48 as=3.48 pd=24.58
+ ps=24.58 nrd=0.0241667 nrs=0.0241667 sa=0 sb=0 sd=0 mult=3 m=3
XIp1d_0_n p1d_a phi1 vssa vssa sky130_fd_pr__nfet_01v8 L=0.5 W=1 nf=1 ad=0.29 as=0.29 pd=2.58
+ ps=2.58 nrd=0.29 nrs=0.29 sa=0 sb=0 sd=0 mult=1 m=1
XIp1d_0_p vdda phi1 p1d_a vdda sky130_fd_pr__pfet_01v8 L=0.5 W=2 nf=1 ad=0.58 as=0.58 pd=4.58
+ ps=4.58 nrd=0.145 nrs=0.145 sa=0 sb=0 sd=0 mult=1 m=1
XIp1d_1_n p1d p1d_a vssa vssa sky130_fd_pr__nfet_01v8 L=0.5 W=1 nf=1 ad=0.29 as=0.29 pd=2.58 ps=2.58
+ nrd=0.29 nrs=0.29 sa=0 sb=0 sd=0 mult=1 m=1
XIp1d_1_p vdda p1d_a p1d vdda sky130_fd_pr__pfet_01v8 L=0.5 W=2 nf=1 ad=0.58 as=0.58 pd=4.58 ps=4.58
+ nrd=0.145 nrs=0.145 sa=0 sb=0 sd=0 mult=1 m=1
XNcore2_na core2 clk vssa vssa sky130_fd_pr__nfet_01v8 L=0.15 W=1 nf=1 ad=0.29 as=0.29 pd=2.58
+ ps=2.58 nrd=0.29 nrs=0.29 sa=0 sb=0 sd=0 mult=1 m=1
XNcore2_nb core2 p1d vssa vssa sky130_fd_pr__nfet_01v8 L=0.15 W=1 nf=1 ad=0.29 as=0.29 pd=2.58
+ ps=2.58 nrd=0.29 nrs=0.29 sa=0 sb=0 sd=0 mult=1 m=1
XNcore2_pa vdda clk Ncore2_m vdda sky130_fd_pr__pfet_01v8 L=0.15 W=4 nf=1 ad=1.16 as=1.16 pd=8.58
+ ps=8.58 nrd=0.0725 nrs=0.0725 sa=0 sb=0 sd=0 mult=1 m=1
XNcore2_pb Ncore2_m p1d core2 vdda sky130_fd_pr__pfet_01v8 L=0.15 W=4 nf=1 ad=1.16 as=1.16 pd=8.58
+ ps=8.58 nrd=0.0725 nrs=0.0725 sa=0 sb=0 sd=0 mult=1 m=1
XIc2a_n c2a core2 vssa vssa sky130_fd_pr__nfet_01v8 L=0.15 W=2 nf=1 ad=0.58 as=0.58 pd=4.58 ps=4.58
+ nrd=0.145 nrs=0.145 sa=0 sb=0 sd=0 mult=1 m=1
XIc2a_p vdda core2 c2a vdda sky130_fd_pr__pfet_01v8 L=0.15 W=4 nf=1 ad=1.16 as=1.16 pd=8.58 ps=8.58
+ nrd=0.0725 nrs=0.0725 sa=0 sb=0 sd=0 mult=1 m=1
XIphi2_n phi2 c2a vssa vssa sky130_fd_pr__nfet_01v8 L=0.15 W=6 nf=1 ad=1.74 as=1.74 pd=12.58
+ ps=12.58 nrd=0.0483333 nrs=0.0483333 sa=0 sb=0 sd=0 mult=4 m=4
XIphi2_p vdda c2a phi2 vdda sky130_fd_pr__pfet_01v8 L=0.15 W=12 nf=1 ad=3.48 as=3.48 pd=24.58
+ ps=24.58 nrd=0.0241667 nrs=0.0241667 sa=0 sb=0 sd=0 mult=4 m=4
XIp2d_0_n p2d_a phi2 vssa vssa sky130_fd_pr__nfet_01v8 L=0.5 W=1 nf=1 ad=0.29 as=0.29 pd=2.58
+ ps=2.58 nrd=0.29 nrs=0.29 sa=0 sb=0 sd=0 mult=1 m=1
XIp2d_0_p vdda phi2 p2d_a vdda sky130_fd_pr__pfet_01v8 L=0.5 W=2 nf=1 ad=0.58 as=0.58 pd=4.58
+ ps=4.58 nrd=0.145 nrs=0.145 sa=0 sb=0 sd=0 mult=1 m=1
XIp2d_1_n p2d p2d_a vssa vssa sky130_fd_pr__nfet_01v8 L=0.5 W=1 nf=1 ad=0.29 as=0.29 pd=2.58 ps=2.58
+ nrd=0.29 nrs=0.29 sa=0 sb=0 sd=0 mult=1 m=1
XIp2d_1_p vdda p2d_a p2d vdda sky130_fd_pr__pfet_01v8 L=0.5 W=2 nf=1 ad=0.58 as=0.58 pd=4.58 ps=4.58
+ nrd=0.145 nrs=0.145 sa=0 sb=0 sd=0 mult=1 m=1
.ends
