* comparator -- sky130-comparator wrapped as a subcircuit (issue #41).
* GENERATED by design/modulator/comparator/wrap_comparator.sh from the
* vendored comparator_core.spice (provenance: PROVENANCE.md). Do not hand-edit.
.subckt comparator vdda vssa clk vinp vinn outp outn
XM_PTAIL TAILP vdda vssa vssa sky130_fd_pr__nfet_01v8 L=0.5 W=0.8 nf=1 ad=0.232 as=0.232 pd=2.18 ps=2.18 nrd=0.3625 nrs=0.3625 sa=0
+ sb=0 sd=0 mult=1 m=1
XM_PINN OUTN1 VINN TAILP vssa sky130_fd_pr__nfet_01v8 L=0.5 W=13 nf=1 ad=3.77 as=3.77 pd=26.58 ps=26.58 nrd=0.0223076923076923
+ nrs=0.0223076923076923 sa=0 sb=0 sd=0 mult=1 m=1
XM_PINP OUTP1 VINP TAILP vssa sky130_fd_pr__nfet_01v8 L=0.5 W=13 nf=1 ad=3.77 as=3.77 pd=26.58 ps=26.58 nrd=0.0223076923076923
+ nrs=0.0223076923076923 sa=0 sb=0 sd=0 mult=1 m=1
XM_TAIL2 TAIL2 CLKT vssa vssa sky130_fd_pr__nfet_01v8 L=0.5 W=8 nf=1 ad=2.32 as=2.32 pd=16.58 ps=16.58 nrd=0.03625 nrs=0.03625 sa=0
+ sb=0 sd=0 mult=1 m=1
XM_STN_P OUTP OUTP1 TAIL2 vssa sky130_fd_pr__nfet_01v8 L=0.5 W=8 nf=1 ad=2.32 as=2.32 pd=16.58 ps=16.58 nrd=0.03625 nrs=0.03625
+ sa=0 sb=0 sd=0 mult=1 m=1
XM_STN_N OUTN OUTN1 TAIL2 vssa sky130_fd_pr__nfet_01v8 L=0.5 W=8 nf=1 ad=2.32 as=2.32 pd=16.58 ps=16.58 nrd=0.03625 nrs=0.03625
+ sa=0 sb=0 sd=0 mult=1 m=1
XM_LATP_P OUTP OUTN vdda vdda sky130_fd_pr__pfet_01v8 L=0.5 W=16 nf=1 ad=4.64 as=4.64 pd=32.58 ps=32.58 nrd=0.018125 nrs=0.018125
+ sa=0 sb=0 sd=0 mult=1 m=1
XM_LATP_N OUTN OUTP vdda vdda sky130_fd_pr__pfet_01v8 L=0.5 W=16 nf=1 ad=4.64 as=4.64 pd=32.58 ps=32.58 nrd=0.018125 nrs=0.018125
+ sa=0 sb=0 sd=0 mult=1 m=1
XM_RST_P OUTP CLKT vdda vdda sky130_fd_pr__pfet_01v8 L=0.5 W=8 nf=1 ad=2.32 as=2.32 pd=16.58 ps=16.58 nrd=0.03625 nrs=0.03625 sa=0
+ sb=0 sd=0 mult=1 m=1
XM_RST_N OUTN CLKT vdda vdda sky130_fd_pr__pfet_01v8 L=0.5 W=8 nf=1 ad=2.32 as=2.32 pd=16.58 ps=16.58 nrd=0.03625 nrs=0.03625 sa=0
+ sb=0 sd=0 mult=1 m=1
XR_LP OUTN1 vdda vssa sky130_fd_pr__res_high_po_0p35 L=22 mult=1 m=1
XR_LN OUTP1 vdda vssa sky130_fd_pr__res_high_po_0p35 L=22 mult=1 m=1
XR_CLKS CLKT CLK vssa sky130_fd_pr__res_high_po_0p35 L=1.75 mult=1 m=1
XM_CLKCAP vssa CLKT vssa vssa sky130_fd_pr__nfet_01v8 L=0.5 W=20 nf=1 ad=5.8 as=5.8 pd=40.58 ps=40.58 nrd=0.0145 nrs=0.0145 sa=0 sb=0
+ sd=0 mult=1 m=1
XM_C1P vssa OUTP1 vssa vssa sky130_fd_pr__nfet_01v8 L=0.5 W=40 nf=1 ad=11.6 as=11.6 pd=80.58 ps=80.58 nrd=0.00725 nrs=0.00725 sa=0
+ sb=0 sd=0 mult=1 m=1
XM_C1N vssa OUTN1 vssa vssa sky130_fd_pr__nfet_01v8 L=0.5 W=40 nf=1 ad=11.6 as=11.6 pd=80.58 ps=80.58 nrd=0.00725 nrs=0.00725 sa=0
+ sb=0 sd=0 mult=1 m=1
.ends comparator
